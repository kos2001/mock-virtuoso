if(ddGetObj("layout_gen" "strongarm_sky130") then "existing" else
let((cv net pin) cv=dbOpenCellViewByType("layout_gen" "strongarm_sky130" "layout" "maskLayout" "a")
dbCreatePolygon(cv list("boundary" "gds_4") list(list(27.21 -1.285) list(27.21 1.285) list(28.79 1.285) list(28.79 -1.285)))
dbCreatePolygon(cv list("boundary" "gds_4") list(list(35.21 -1.285) list(35.21 1.285) list(36.79 1.285) list(36.79 -1.285)))
dbCreatePolygon(cv list("boundary" "gds_4") list(list(43.21 -1.33) list(43.21 1.33) list(44.79 1.33) list(44.79 -1.33)))
dbCreatePolygon(cv list("boundary" "gds_4") list(list(51.21 -1.33) list(51.21 1.33) list(52.79 1.33) list(52.79 -1.33)))
dbCreatePolygon(cv list("boundary" "gds_4") list(list(59.21 -1.33) list(59.21 1.33) list(60.79 1.33) list(60.79 -1.33)))
dbCreatePolygon(cv list("boundary" "gds_4") list(list(67.21 -1.33) list(67.21 1.33) list(68.79 1.33) list(68.79 -1.33)))
dbCreatePolygon(cv list("boundary" "gds_4") list(list(75.21 -1.33) list(75.21 1.33) list(76.79 1.33) list(76.79 -1.33)))
dbCreatePolygon(cv list("boundary" "gds_4") list(list(83.21 -1.33) list(83.21 1.33) list(84.79 1.33) list(84.79 -1.33)))
dbCreatePolygon(cv list("boundary" "gds_4") list(list(11.21 -1.785) list(11.21 1.785) list(12.79 1.785) list(12.79 -1.785)))
dbCreatePolygon(cv list("boundary" "gds_4") list(list(19.21 -1.785) list(19.21 1.785) list(20.79 1.785) list(20.79 -1.785)))
dbCreatePolygon(cv list("boundary" "gds_4") list(list(3.21 -2.785) list(3.21 2.785) list(4.79 2.785) list(4.79 -2.785)))
dbCreatePolygon(cv list("diff" "drawing") list(list(27.635 -0.5) list(27.635 0.5) list(28.365 0.5) list(28.365 -0.5)))
dbCreatePolygon(cv list("diff" "drawing") list(list(35.635 -0.5) list(35.635 0.5) list(36.365 0.5) list(36.365 -0.5)))
dbCreatePolygon(cv list("diff" "drawing") list(list(43.635 -0.5) list(43.635 0.5) list(44.365 0.5) list(44.365 -0.5)))
dbCreatePolygon(cv list("diff" "drawing") list(list(51.635 -0.5) list(51.635 0.5) list(52.365 0.5) list(52.365 -0.5)))
dbCreatePolygon(cv list("diff" "drawing") list(list(59.635 -0.5) list(59.635 0.5) list(60.365 0.5) list(60.365 -0.5)))
dbCreatePolygon(cv list("diff" "drawing") list(list(67.635 -0.5) list(67.635 0.5) list(68.365 0.5) list(68.365 -0.5)))
dbCreatePolygon(cv list("diff" "drawing") list(list(75.635 -0.5) list(75.635 0.5) list(76.365 0.5) list(76.365 -0.5)))
dbCreatePolygon(cv list("diff" "drawing") list(list(83.635 -0.5) list(83.635 0.5) list(84.365 0.5) list(84.365 -0.5)))
dbCreatePolygon(cv list("diff" "drawing") list(list(11.635 -1) list(11.635 1) list(12.365 1) list(12.365 -1)))
dbCreatePolygon(cv list("diff" "drawing") list(list(19.635 -1) list(19.635 1) list(20.365 1) list(20.365 -1)))
dbCreatePolygon(cv list("diff" "drawing") list(list(3.635 -2) list(3.635 2) list(4.365 2) list(4.365 -2)))
dbCreatePolygon(cv list("tap" "gds_44") list(list(27.125 -1.37) list(27.125 -1.2) list(28.875 -1.2) list(28.875 -1.37)))
dbCreatePolygon(cv list("tap" "gds_44") list(list(27.125 -1.2) list(27.125 1.2) list(27.295 1.2) list(27.295 -1.2)))
dbCreatePolygon(cv list("tap" "gds_44") list(list(28.705 -1.2) list(28.705 1.2) list(28.875 1.2) list(28.875 -1.2)))
dbCreatePolygon(cv list("tap" "gds_44") list(list(27.125 1.2) list(27.125 1.37) list(28.875 1.37) list(28.875 1.2)))
dbCreatePolygon(cv list("tap" "gds_44") list(list(35.125 -1.37) list(35.125 -1.2) list(36.875 -1.2) list(36.875 -1.37)))
dbCreatePolygon(cv list("tap" "gds_44") list(list(35.125 -1.2) list(35.125 1.2) list(35.295 1.2) list(35.295 -1.2)))
dbCreatePolygon(cv list("tap" "gds_44") list(list(36.705 -1.2) list(36.705 1.2) list(36.875 1.2) list(36.875 -1.2)))
dbCreatePolygon(cv list("tap" "gds_44") list(list(35.125 1.2) list(35.125 1.37) list(36.875 1.37) list(36.875 1.2)))
dbCreatePolygon(cv list("tap" "gds_44") list(list(43.125 -1.415) list(43.125 -1.245) list(44.875 -1.245) list(44.875 -1.415)))
dbCreatePolygon(cv list("tap" "gds_44") list(list(43.125 -1.245) list(43.125 1.245) list(43.295 1.245) list(43.295 -1.245)))
dbCreatePolygon(cv list("tap" "gds_44") list(list(44.705 -1.245) list(44.705 1.245) list(44.875 1.245) list(44.875 -1.245)))
dbCreatePolygon(cv list("tap" "gds_44") list(list(43.125 1.245) list(43.125 1.415) list(44.875 1.415) list(44.875 1.245)))
dbCreatePolygon(cv list("tap" "gds_44") list(list(51.125 -1.415) list(51.125 -1.245) list(52.875 -1.245) list(52.875 -1.415)))
dbCreatePolygon(cv list("tap" "gds_44") list(list(51.125 -1.245) list(51.125 1.245) list(51.295 1.245) list(51.295 -1.245)))
dbCreatePolygon(cv list("tap" "gds_44") list(list(52.705 -1.245) list(52.705 1.245) list(52.875 1.245) list(52.875 -1.245)))
dbCreatePolygon(cv list("tap" "gds_44") list(list(51.125 1.245) list(51.125 1.415) list(52.875 1.415) list(52.875 1.245)))
dbCreatePolygon(cv list("tap" "gds_44") list(list(59.125 -1.415) list(59.125 -1.245) list(60.875 -1.245) list(60.875 -1.415)))
dbCreatePolygon(cv list("tap" "gds_44") list(list(59.125 -1.245) list(59.125 1.245) list(59.295 1.245) list(59.295 -1.245)))
dbCreatePolygon(cv list("tap" "gds_44") list(list(60.705 -1.245) list(60.705 1.245) list(60.875 1.245) list(60.875 -1.245)))
dbCreatePolygon(cv list("tap" "gds_44") list(list(59.125 1.245) list(59.125 1.415) list(60.875 1.415) list(60.875 1.245)))
dbCreatePolygon(cv list("tap" "gds_44") list(list(67.125 -1.415) list(67.125 -1.245) list(68.875 -1.245) list(68.875 -1.415)))
dbCreatePolygon(cv list("tap" "gds_44") list(list(67.125 -1.245) list(67.125 1.245) list(67.295 1.245) list(67.295 -1.245)))
dbCreatePolygon(cv list("tap" "gds_44") list(list(68.705 -1.245) list(68.705 1.245) list(68.875 1.245) list(68.875 -1.245)))
dbCreatePolygon(cv list("tap" "gds_44") list(list(67.125 1.245) list(67.125 1.415) list(68.875 1.415) list(68.875 1.245)))
dbCreatePolygon(cv list("tap" "gds_44") list(list(75.125 -1.415) list(75.125 -1.245) list(76.875 -1.245) list(76.875 -1.415)))
dbCreatePolygon(cv list("tap" "gds_44") list(list(75.125 -1.245) list(75.125 1.245) list(75.295 1.245) list(75.295 -1.245)))
dbCreatePolygon(cv list("tap" "gds_44") list(list(76.705 -1.245) list(76.705 1.245) list(76.875 1.245) list(76.875 -1.245)))
dbCreatePolygon(cv list("tap" "gds_44") list(list(75.125 1.245) list(75.125 1.415) list(76.875 1.415) list(76.875 1.245)))
dbCreatePolygon(cv list("tap" "gds_44") list(list(83.125 -1.415) list(83.125 -1.245) list(84.875 -1.245) list(84.875 -1.415)))
dbCreatePolygon(cv list("tap" "gds_44") list(list(83.125 -1.245) list(83.125 1.245) list(83.295 1.245) list(83.295 -1.245)))
dbCreatePolygon(cv list("tap" "gds_44") list(list(84.705 -1.245) list(84.705 1.245) list(84.875 1.245) list(84.875 -1.245)))
dbCreatePolygon(cv list("tap" "gds_44") list(list(83.125 1.245) list(83.125 1.415) list(84.875 1.415) list(84.875 1.245)))
dbCreatePolygon(cv list("tap" "gds_44") list(list(11.125 -1.87) list(11.125 -1.7) list(12.875 -1.7) list(12.875 -1.87)))
dbCreatePolygon(cv list("tap" "gds_44") list(list(11.125 -1.7) list(11.125 1.7) list(11.295 1.7) list(11.295 -1.7)))
dbCreatePolygon(cv list("tap" "gds_44") list(list(12.705 -1.7) list(12.705 1.7) list(12.875 1.7) list(12.875 -1.7)))
dbCreatePolygon(cv list("tap" "gds_44") list(list(11.125 1.7) list(11.125 1.87) list(12.875 1.87) list(12.875 1.7)))
dbCreatePolygon(cv list("tap" "gds_44") list(list(19.125 -1.87) list(19.125 -1.7) list(20.875 -1.7) list(20.875 -1.87)))
dbCreatePolygon(cv list("tap" "gds_44") list(list(19.125 -1.7) list(19.125 1.7) list(19.295 1.7) list(19.295 -1.7)))
dbCreatePolygon(cv list("tap" "gds_44") list(list(20.705 -1.7) list(20.705 1.7) list(20.875 1.7) list(20.875 -1.7)))
dbCreatePolygon(cv list("tap" "gds_44") list(list(19.125 1.7) list(19.125 1.87) list(20.875 1.87) list(20.875 1.7)))
dbCreatePolygon(cv list("tap" "gds_44") list(list(3.125 -2.87) list(3.125 -2.7) list(4.875 -2.7) list(4.875 -2.87)))
dbCreatePolygon(cv list("tap" "gds_44") list(list(3.125 -2.7) list(3.125 2.7) list(3.295 2.7) list(3.295 -2.7)))
dbCreatePolygon(cv list("tap" "gds_44") list(list(4.705 -2.7) list(4.705 2.7) list(4.875 2.7) list(4.875 -2.7)))
dbCreatePolygon(cv list("tap" "gds_44") list(list(3.125 2.7) list(3.125 2.87) list(4.875 2.87) list(4.875 2.7)))
dbCreatePolygon(cv list("psdm" "drawing") list(list(43.51 -0.625) list(43.51 0.625) list(44.49 0.625) list(44.49 -0.625)))
dbCreatePolygon(cv list("psdm" "drawing") list(list(51.51 -0.625) list(51.51 0.625) list(52.49 0.625) list(52.49 -0.625)))
dbCreatePolygon(cv list("psdm" "drawing") list(list(59.51 -0.625) list(59.51 0.625) list(60.49 0.625) list(60.49 -0.625)))
dbCreatePolygon(cv list("psdm" "drawing") list(list(67.51 -0.625) list(67.51 0.625) list(68.49 0.625) list(68.49 -0.625)))
dbCreatePolygon(cv list("psdm" "drawing") list(list(75.51 -0.625) list(75.51 0.625) list(76.49 0.625) list(76.49 -0.625)))
dbCreatePolygon(cv list("psdm" "drawing") list(list(83.51 -0.625) list(83.51 0.625) list(84.49 0.625) list(84.49 -0.625)))
dbCreatePolygon(cv list("psdm" "drawing") list(list(27 -1.495) list(27 -1.075) list(29 -1.075) list(29 -1.495)))
dbCreatePolygon(cv list("psdm" "drawing") list(list(27 -1.075) list(27 1.075) list(27.42 1.075) list(27.42 -1.075)))
dbCreatePolygon(cv list("psdm" "drawing") list(list(28.58 -1.075) list(28.58 1.075) list(29 1.075) list(29 -1.075)))
dbCreatePolygon(cv list("psdm" "drawing") list(list(27 1.075) list(27 1.495) list(29 1.495) list(29 1.075)))
dbCreatePolygon(cv list("psdm" "drawing") list(list(35 -1.495) list(35 -1.075) list(37 -1.075) list(37 -1.495)))
dbCreatePolygon(cv list("psdm" "drawing") list(list(35 -1.075) list(35 1.075) list(35.42 1.075) list(35.42 -1.075)))
dbCreatePolygon(cv list("psdm" "drawing") list(list(36.58 -1.075) list(36.58 1.075) list(37 1.075) list(37 -1.075)))
dbCreatePolygon(cv list("psdm" "drawing") list(list(35 1.075) list(35 1.495) list(37 1.495) list(37 1.075)))
dbCreatePolygon(cv list("psdm" "drawing") list(list(11 -1.995) list(11 -1.575) list(13 -1.575) list(13 -1.995)))
dbCreatePolygon(cv list("psdm" "drawing") list(list(11 -1.575) list(11 1.575) list(11.42 1.575) list(11.42 -1.575)))
dbCreatePolygon(cv list("psdm" "drawing") list(list(12.58 -1.575) list(12.58 1.575) list(13 1.575) list(13 -1.575)))
dbCreatePolygon(cv list("psdm" "drawing") list(list(11 1.575) list(11 1.995) list(13 1.995) list(13 1.575)))
dbCreatePolygon(cv list("psdm" "drawing") list(list(19 -1.995) list(19 -1.575) list(21 -1.575) list(21 -1.995)))
dbCreatePolygon(cv list("psdm" "drawing") list(list(19 -1.575) list(19 1.575) list(19.42 1.575) list(19.42 -1.575)))
dbCreatePolygon(cv list("psdm" "drawing") list(list(20.58 -1.575) list(20.58 1.575) list(21 1.575) list(21 -1.575)))
dbCreatePolygon(cv list("psdm" "drawing") list(list(19 1.575) list(19 1.995) list(21 1.995) list(21 1.575)))
dbCreatePolygon(cv list("psdm" "drawing") list(list(3 -2.995) list(3 -2.575) list(5 -2.575) list(5 -2.995)))
dbCreatePolygon(cv list("psdm" "drawing") list(list(3 -2.575) list(3 2.575) list(3.42 2.575) list(3.42 -2.575)))
dbCreatePolygon(cv list("psdm" "drawing") list(list(4.58 -2.575) list(4.58 2.575) list(5 2.575) list(5 -2.575)))
dbCreatePolygon(cv list("psdm" "drawing") list(list(3 2.575) list(3 2.995) list(5 2.995) list(5 2.575)))
dbCreatePolygon(cv list("nsdm" "gds_44") list(list(27.51 -0.625) list(27.51 0.625) list(28.49 0.625) list(28.49 -0.625)))
dbCreatePolygon(cv list("nsdm" "gds_44") list(list(35.51 -0.625) list(35.51 0.625) list(36.49 0.625) list(36.49 -0.625)))
dbCreatePolygon(cv list("nsdm" "gds_44") list(list(11.51 -1.125) list(11.51 1.125) list(12.49 1.125) list(12.49 -1.125)))
dbCreatePolygon(cv list("nsdm" "gds_44") list(list(19.51 -1.125) list(19.51 1.125) list(20.49 1.125) list(20.49 -1.125)))
dbCreatePolygon(cv list("nsdm" "gds_44") list(list(43 -1.54) list(43 -1.12) list(45 -1.12) list(45 -1.54)))
dbCreatePolygon(cv list("nsdm" "gds_44") list(list(43 -1.12) list(43 1.12) list(43.42 1.12) list(43.42 -1.12)))
dbCreatePolygon(cv list("nsdm" "gds_44") list(list(44.58 -1.12) list(44.58 1.12) list(45 1.12) list(45 -1.12)))
dbCreatePolygon(cv list("nsdm" "gds_44") list(list(43 1.12) list(43 1.54) list(45 1.54) list(45 1.12)))
dbCreatePolygon(cv list("nsdm" "gds_44") list(list(51 -1.54) list(51 -1.12) list(53 -1.12) list(53 -1.54)))
dbCreatePolygon(cv list("nsdm" "gds_44") list(list(51 -1.12) list(51 1.12) list(51.42 1.12) list(51.42 -1.12)))
dbCreatePolygon(cv list("nsdm" "gds_44") list(list(52.58 -1.12) list(52.58 1.12) list(53 1.12) list(53 -1.12)))
dbCreatePolygon(cv list("nsdm" "gds_44") list(list(51 1.12) list(51 1.54) list(53 1.54) list(53 1.12)))
dbCreatePolygon(cv list("nsdm" "gds_44") list(list(59 -1.54) list(59 -1.12) list(61 -1.12) list(61 -1.54)))
dbCreatePolygon(cv list("nsdm" "gds_44") list(list(59 -1.12) list(59 1.12) list(59.42 1.12) list(59.42 -1.12)))
dbCreatePolygon(cv list("nsdm" "gds_44") list(list(60.58 -1.12) list(60.58 1.12) list(61 1.12) list(61 -1.12)))
dbCreatePolygon(cv list("nsdm" "gds_44") list(list(59 1.12) list(59 1.54) list(61 1.54) list(61 1.12)))
dbCreatePolygon(cv list("nsdm" "gds_44") list(list(67 -1.54) list(67 -1.12) list(69 -1.12) list(69 -1.54)))
dbCreatePolygon(cv list("nsdm" "gds_44") list(list(67 -1.12) list(67 1.12) list(67.42 1.12) list(67.42 -1.12)))
dbCreatePolygon(cv list("nsdm" "gds_44") list(list(68.58 -1.12) list(68.58 1.12) list(69 1.12) list(69 -1.12)))
dbCreatePolygon(cv list("nsdm" "gds_44") list(list(67 1.12) list(67 1.54) list(69 1.54) list(69 1.12)))
dbCreatePolygon(cv list("nsdm" "gds_44") list(list(75 -1.54) list(75 -1.12) list(77 -1.12) list(77 -1.54)))
dbCreatePolygon(cv list("nsdm" "gds_44") list(list(75 -1.12) list(75 1.12) list(75.42 1.12) list(75.42 -1.12)))
dbCreatePolygon(cv list("nsdm" "gds_44") list(list(76.58 -1.12) list(76.58 1.12) list(77 1.12) list(77 -1.12)))
dbCreatePolygon(cv list("nsdm" "gds_44") list(list(75 1.12) list(75 1.54) list(77 1.54) list(77 1.12)))
dbCreatePolygon(cv list("nsdm" "gds_44") list(list(83 -1.54) list(83 -1.12) list(85 -1.12) list(85 -1.54)))
dbCreatePolygon(cv list("nsdm" "gds_44") list(list(83 -1.12) list(83 1.12) list(83.42 1.12) list(83.42 -1.12)))
dbCreatePolygon(cv list("nsdm" "gds_44") list(list(84.58 -1.12) list(84.58 1.12) list(85 1.12) list(85 -1.12)))
dbCreatePolygon(cv list("nsdm" "gds_44") list(list(83 1.12) list(83 1.54) list(85 1.54) list(85 1.12)))
dbCreatePolygon(cv list("nsdm" "gds_44") list(list(3.51 -2.125) list(3.51 2.125) list(4.49 2.125) list(4.49 -2.125)))
dbCreatePolygon(cv list("poly" "drawing") list(list(27.835 -0.94) list(27.835 -0.61) list(28.165 -0.61) list(28.165 -0.94)))
dbCreatePolygon(cv list("poly" "drawing") list(list(27.925 -0.61) list(27.925 0.61) list(28.075 0.61) list(28.075 -0.61)))
dbCreatePolygon(cv list("poly" "drawing") list(list(27.835 0.61) list(27.835 0.94) list(28.165 0.94) list(28.165 0.61)))
dbCreatePolygon(cv list("poly" "drawing") list(list(35.835 -0.94) list(35.835 -0.61) list(36.165 -0.61) list(36.165 -0.94)))
dbCreatePolygon(cv list("poly" "drawing") list(list(35.925 -0.61) list(35.925 0.61) list(36.075 0.61) list(36.075 -0.61)))
dbCreatePolygon(cv list("poly" "drawing") list(list(35.835 0.61) list(35.835 0.94) list(36.165 0.94) list(36.165 0.61)))
dbCreatePolygon(cv list("poly" "drawing") list(list(43.835 -0.985) list(43.835 -0.655) list(44.165 -0.655) list(44.165 -0.985)))
dbCreatePolygon(cv list("poly" "drawing") list(list(43.925 -0.655) list(43.925 0.655) list(44.075 0.655) list(44.075 -0.655)))
dbCreatePolygon(cv list("poly" "drawing") list(list(43.835 0.655) list(43.835 0.985) list(44.165 0.985) list(44.165 0.655)))
dbCreatePolygon(cv list("poly" "drawing") list(list(51.835 -0.985) list(51.835 -0.655) list(52.165 -0.655) list(52.165 -0.985)))
dbCreatePolygon(cv list("poly" "drawing") list(list(51.925 -0.655) list(51.925 0.655) list(52.075 0.655) list(52.075 -0.655)))
dbCreatePolygon(cv list("poly" "drawing") list(list(51.835 0.655) list(51.835 0.985) list(52.165 0.985) list(52.165 0.655)))
dbCreatePolygon(cv list("poly" "drawing") list(list(59.835 -0.985) list(59.835 -0.655) list(60.165 -0.655) list(60.165 -0.985)))
dbCreatePolygon(cv list("poly" "drawing") list(list(59.925 -0.655) list(59.925 0.655) list(60.075 0.655) list(60.075 -0.655)))
dbCreatePolygon(cv list("poly" "drawing") list(list(59.835 0.655) list(59.835 0.985) list(60.165 0.985) list(60.165 0.655)))
dbCreatePolygon(cv list("poly" "drawing") list(list(67.835 -0.985) list(67.835 -0.655) list(68.165 -0.655) list(68.165 -0.985)))
dbCreatePolygon(cv list("poly" "drawing") list(list(67.925 -0.655) list(67.925 0.655) list(68.075 0.655) list(68.075 -0.655)))
dbCreatePolygon(cv list("poly" "drawing") list(list(67.835 0.655) list(67.835 0.985) list(68.165 0.985) list(68.165 0.655)))
dbCreatePolygon(cv list("poly" "drawing") list(list(75.835 -0.985) list(75.835 -0.655) list(76.165 -0.655) list(76.165 -0.985)))
dbCreatePolygon(cv list("poly" "drawing") list(list(75.925 -0.655) list(75.925 0.655) list(76.075 0.655) list(76.075 -0.655)))
dbCreatePolygon(cv list("poly" "drawing") list(list(75.835 0.655) list(75.835 0.985) list(76.165 0.985) list(76.165 0.655)))
dbCreatePolygon(cv list("poly" "drawing") list(list(83.835 -0.985) list(83.835 -0.655) list(84.165 -0.655) list(84.165 -0.985)))
dbCreatePolygon(cv list("poly" "drawing") list(list(83.925 -0.655) list(83.925 0.655) list(84.075 0.655) list(84.075 -0.655)))
dbCreatePolygon(cv list("poly" "drawing") list(list(83.835 0.655) list(83.835 0.985) list(84.165 0.985) list(84.165 0.655)))
dbCreatePolygon(cv list("poly" "drawing") list(list(11.835 -1.44) list(11.835 -1.11) list(12.165 -1.11) list(12.165 -1.44)))
dbCreatePolygon(cv list("poly" "drawing") list(list(11.925 -1.11) list(11.925 1.11) list(12.075 1.11) list(12.075 -1.11)))
dbCreatePolygon(cv list("poly" "drawing") list(list(11.835 1.11) list(11.835 1.44) list(12.165 1.44) list(12.165 1.11)))
dbCreatePolygon(cv list("poly" "drawing") list(list(19.835 -1.44) list(19.835 -1.11) list(20.165 -1.11) list(20.165 -1.44)))
dbCreatePolygon(cv list("poly" "drawing") list(list(19.925 -1.11) list(19.925 1.11) list(20.075 1.11) list(20.075 -1.11)))
dbCreatePolygon(cv list("poly" "drawing") list(list(19.835 1.11) list(19.835 1.44) list(20.165 1.44) list(20.165 1.11)))
dbCreatePolygon(cv list("poly" "drawing") list(list(3.835 -2.44) list(3.835 -2.11) list(4.165 -2.11) list(4.165 -2.44)))
dbCreatePolygon(cv list("poly" "drawing") list(list(3.925 -2.11) list(3.925 2.11) list(4.075 2.11) list(4.075 -2.11)))
dbCreatePolygon(cv list("poly" "drawing") list(list(3.835 2.11) list(3.835 2.44) list(4.165 2.44) list(4.165 2.11)))
dbCreatePolygon(cv list("licon1" "gds_44") list(list(43.915 -0.905) list(43.915 -0.735) list(44.085 -0.735) list(44.085 -0.905)))
dbCreatePolygon(cv list("licon1" "gds_44") list(list(43.915 0.735) list(43.915 0.905) list(44.085 0.905) list(44.085 0.735)))
dbCreatePolygon(cv list("licon1" "gds_44") list(list(67.745 -1.415) list(67.745 -1.245) list(67.915 -1.245) list(67.915 -1.415)))
dbCreatePolygon(cv list("licon1" "gds_44") list(list(68.085 -1.415) list(68.085 -1.245) list(68.255 -1.245) list(68.255 -1.415)))
dbCreatePolygon(cv list("licon1" "gds_44") list(list(75.745 -1.415) list(75.745 -1.245) list(75.915 -1.245) list(75.915 -1.415)))
dbCreatePolygon(cv list("licon1" "gds_44") list(list(76.085 -1.415) list(76.085 -1.245) list(76.255 -1.245) list(76.255 -1.415)))
dbCreatePolygon(cv list("licon1" "gds_44") list(list(83.745 -1.415) list(83.745 -1.245) list(83.915 -1.245) list(83.915 -1.415)))
dbCreatePolygon(cv list("licon1" "gds_44") list(list(84.085 -1.415) list(84.085 -1.245) list(84.255 -1.245) list(84.255 -1.415)))
dbCreatePolygon(cv list("licon1" "gds_44") list(list(67.125 -0.935) list(67.125 -0.765) list(67.295 -0.765) list(67.295 -0.935)))
dbCreatePolygon(cv list("licon1" "gds_44") list(list(68.705 -0.935) list(68.705 -0.765) list(68.875 -0.765) list(68.875 -0.935)))
dbCreatePolygon(cv list("licon1" "gds_44") list(list(75.125 -0.935) list(75.125 -0.765) list(75.295 -0.765) list(75.295 -0.935)))
dbCreatePolygon(cv list("licon1" "gds_44") list(list(76.705 -0.935) list(76.705 -0.765) list(76.875 -0.765) list(76.875 -0.935)))
dbCreatePolygon(cv list("licon1" "gds_44") list(list(83.125 -0.935) list(83.125 -0.765) list(83.295 -0.765) list(83.295 -0.935)))
dbCreatePolygon(cv list("licon1" "gds_44") list(list(84.705 -0.935) list(84.705 -0.765) list(84.875 -0.765) list(84.875 -0.935)))
dbCreatePolygon(cv list("licon1" "gds_44") list(list(67.915 -0.905) list(67.915 -0.735) list(68.085 -0.735) list(68.085 -0.905)))
dbCreatePolygon(cv list("licon1" "gds_44") list(list(75.915 -0.905) list(75.915 -0.735) list(76.085 -0.735) list(76.085 -0.905)))
dbCreatePolygon(cv list("licon1" "gds_44") list(list(83.915 -0.905) list(83.915 -0.735) list(84.085 -0.735) list(84.085 -0.905)))
dbCreatePolygon(cv list("licon1" "gds_44") list(list(67.125 -0.595) list(67.125 -0.425) list(67.295 -0.425) list(67.295 -0.595)))
dbCreatePolygon(cv list("licon1" "gds_44") list(list(68.705 -0.595) list(68.705 -0.425) list(68.875 -0.425) list(68.875 -0.595)))
dbCreatePolygon(cv list("licon1" "gds_44") list(list(75.125 -0.595) list(75.125 -0.425) list(75.295 -0.425) list(75.295 -0.595)))
dbCreatePolygon(cv list("licon1" "gds_44") list(list(76.705 -0.595) list(76.705 -0.425) list(76.875 -0.425) list(76.875 -0.595)))
dbCreatePolygon(cv list("licon1" "gds_44") list(list(83.125 -0.595) list(83.125 -0.425) list(83.295 -0.425) list(83.295 -0.595)))
dbCreatePolygon(cv list("licon1" "gds_44") list(list(84.705 -0.595) list(84.705 -0.425) list(84.875 -0.425) list(84.875 -0.595)))
dbCreatePolygon(cv list("licon1" "gds_44") list(list(67.695 -0.425) list(67.695 -0.255) list(67.865 -0.255) list(67.865 -0.425)))
dbCreatePolygon(cv list("licon1" "gds_44") list(list(68.135 -0.425) list(68.135 -0.255) list(68.305 -0.255) list(68.305 -0.425)))
dbCreatePolygon(cv list("licon1" "gds_44") list(list(75.695 -0.425) list(75.695 -0.255) list(75.865 -0.255) list(75.865 -0.425)))
dbCreatePolygon(cv list("licon1" "gds_44") list(list(76.135 -0.425) list(76.135 -0.255) list(76.305 -0.255) list(76.305 -0.425)))
dbCreatePolygon(cv list("licon1" "gds_44") list(list(83.695 -0.425) list(83.695 -0.255) list(83.865 -0.255) list(83.865 -0.425)))
dbCreatePolygon(cv list("licon1" "gds_44") list(list(84.135 -0.425) list(84.135 -0.255) list(84.305 -0.255) list(84.305 -0.425)))
dbCreatePolygon(cv list("licon1" "gds_44") list(list(67.125 -0.255) list(67.125 -0.085) list(67.295 -0.085) list(67.295 -0.255)))
dbCreatePolygon(cv list("licon1" "gds_44") list(list(68.705 -0.255) list(68.705 -0.085) list(68.875 -0.085) list(68.875 -0.255)))
dbCreatePolygon(cv list("licon1" "gds_44") list(list(75.125 -0.255) list(75.125 -0.085) list(75.295 -0.085) list(75.295 -0.255)))
dbCreatePolygon(cv list("licon1" "gds_44") list(list(76.705 -0.255) list(76.705 -0.085) list(76.875 -0.085) list(76.875 -0.255)))
dbCreatePolygon(cv list("licon1" "gds_44") list(list(83.125 -0.255) list(83.125 -0.085) list(83.295 -0.085) list(83.295 -0.255)))
dbCreatePolygon(cv list("licon1" "gds_44") list(list(84.705 -0.255) list(84.705 -0.085) list(84.875 -0.085) list(84.875 -0.255)))
dbCreatePolygon(cv list("licon1" "gds_44") list(list(67.695 -0.085) list(67.695 0.085) list(67.865 0.085) list(67.865 -0.085)))
dbCreatePolygon(cv list("licon1" "gds_44") list(list(68.135 -0.085) list(68.135 0.085) list(68.305 0.085) list(68.305 -0.085)))
dbCreatePolygon(cv list("licon1" "gds_44") list(list(75.695 -0.085) list(75.695 0.085) list(75.865 0.085) list(75.865 -0.085)))
dbCreatePolygon(cv list("licon1" "gds_44") list(list(76.135 -0.085) list(76.135 0.085) list(76.305 0.085) list(76.305 -0.085)))
dbCreatePolygon(cv list("licon1" "gds_44") list(list(83.695 -0.085) list(83.695 0.085) list(83.865 0.085) list(83.865 -0.085)))
dbCreatePolygon(cv list("licon1" "gds_44") list(list(84.135 -0.085) list(84.135 0.085) list(84.305 0.085) list(84.305 -0.085)))
dbCreatePolygon(cv list("licon1" "gds_44") list(list(67.125 0.085) list(67.125 0.255) list(67.295 0.255) list(67.295 0.085)))
dbCreatePolygon(cv list("licon1" "gds_44") list(list(68.705 0.085) list(68.705 0.255) list(68.875 0.255) list(68.875 0.085)))
dbCreatePolygon(cv list("licon1" "gds_44") list(list(75.125 0.085) list(75.125 0.255) list(75.295 0.255) list(75.295 0.085)))
dbCreatePolygon(cv list("licon1" "gds_44") list(list(76.705 0.085) list(76.705 0.255) list(76.875 0.255) list(76.875 0.085)))
dbCreatePolygon(cv list("licon1" "gds_44") list(list(83.125 0.085) list(83.125 0.255) list(83.295 0.255) list(83.295 0.085)))
dbCreatePolygon(cv list("licon1" "gds_44") list(list(84.705 0.085) list(84.705 0.255) list(84.875 0.255) list(84.875 0.085)))
dbCreatePolygon(cv list("licon1" "gds_44") list(list(67.695 0.255) list(67.695 0.425) list(67.865 0.425) list(67.865 0.255)))
dbCreatePolygon(cv list("licon1" "gds_44") list(list(68.135 0.255) list(68.135 0.425) list(68.305 0.425) list(68.305 0.255)))
dbCreatePolygon(cv list("licon1" "gds_44") list(list(75.695 0.255) list(75.695 0.425) list(75.865 0.425) list(75.865 0.255)))
dbCreatePolygon(cv list("licon1" "gds_44") list(list(76.135 0.255) list(76.135 0.425) list(76.305 0.425) list(76.305 0.255)))
dbCreatePolygon(cv list("licon1" "gds_44") list(list(83.695 0.255) list(83.695 0.425) list(83.865 0.425) list(83.865 0.255)))
dbCreatePolygon(cv list("licon1" "gds_44") list(list(84.135 0.255) list(84.135 0.425) list(84.305 0.425) list(84.305 0.255)))
dbCreatePolygon(cv list("licon1" "gds_44") list(list(67.125 0.425) list(67.125 0.595) list(67.295 0.595) list(67.295 0.425)))
dbCreatePolygon(cv list("licon1" "gds_44") list(list(68.705 0.425) list(68.705 0.595) list(68.875 0.595) list(68.875 0.425)))
dbCreatePolygon(cv list("licon1" "gds_44") list(list(75.125 0.425) list(75.125 0.595) list(75.295 0.595) list(75.295 0.425)))
dbCreatePolygon(cv list("licon1" "gds_44") list(list(76.705 0.425) list(76.705 0.595) list(76.875 0.595) list(76.875 0.425)))
dbCreatePolygon(cv list("licon1" "gds_44") list(list(83.125 0.425) list(83.125 0.595) list(83.295 0.595) list(83.295 0.425)))
dbCreatePolygon(cv list("licon1" "gds_44") list(list(84.705 0.425) list(84.705 0.595) list(84.875 0.595) list(84.875 0.425)))
dbCreatePolygon(cv list("licon1" "gds_44") list(list(67.915 0.735) list(67.915 0.905) list(68.085 0.905) list(68.085 0.735)))
dbCreatePolygon(cv list("licon1" "gds_44") list(list(75.915 0.735) list(75.915 0.905) list(76.085 0.905) list(76.085 0.735)))
dbCreatePolygon(cv list("licon1" "gds_44") list(list(83.915 0.735) list(83.915 0.905) list(84.085 0.905) list(84.085 0.735)))
dbCreatePolygon(cv list("licon1" "gds_44") list(list(67.125 0.765) list(67.125 0.935) list(67.295 0.935) list(67.295 0.765)))
dbCreatePolygon(cv list("licon1" "gds_44") list(list(68.705 0.765) list(68.705 0.935) list(68.875 0.935) list(68.875 0.765)))
dbCreatePolygon(cv list("licon1" "gds_44") list(list(75.125 0.765) list(75.125 0.935) list(75.295 0.935) list(75.295 0.765)))
dbCreatePolygon(cv list("licon1" "gds_44") list(list(76.705 0.765) list(76.705 0.935) list(76.875 0.935) list(76.875 0.765)))
dbCreatePolygon(cv list("licon1" "gds_44") list(list(83.125 0.765) list(83.125 0.935) list(83.295 0.935) list(83.295 0.765)))
dbCreatePolygon(cv list("licon1" "gds_44") list(list(84.705 0.765) list(84.705 0.935) list(84.875 0.935) list(84.875 0.765)))
dbCreatePolygon(cv list("licon1" "gds_44") list(list(67.745 1.245) list(67.745 1.415) list(67.915 1.415) list(67.915 1.245)))
dbCreatePolygon(cv list("licon1" "gds_44") list(list(68.085 1.245) list(68.085 1.415) list(68.255 1.415) list(68.255 1.245)))
dbCreatePolygon(cv list("licon1" "gds_44") list(list(75.745 1.245) list(75.745 1.415) list(75.915 1.415) list(75.915 1.245)))
dbCreatePolygon(cv list("licon1" "gds_44") list(list(76.085 1.245) list(76.085 1.415) list(76.255 1.415) list(76.255 1.245)))
dbCreatePolygon(cv list("licon1" "gds_44") list(list(83.745 1.245) list(83.745 1.415) list(83.915 1.415) list(83.915 1.245)))
dbCreatePolygon(cv list("licon1" "gds_44") list(list(84.085 1.245) list(84.085 1.415) list(84.255 1.415) list(84.255 1.245)))
dbCreatePolygon(cv list("licon1" "gds_44") list(list(52.705 0.085) list(52.705 0.255) list(52.875 0.255) list(52.875 0.085)))
dbCreatePolygon(cv list("licon1" "gds_44") list(list(59.125 0.085) list(59.125 0.255) list(59.295 0.255) list(59.295 0.085)))
dbCreatePolygon(cv list("licon1" "gds_44") list(list(60.705 0.085) list(60.705 0.255) list(60.875 0.255) list(60.875 0.085)))
dbCreatePolygon(cv list("licon1" "gds_44") list(list(52.135 -0.425) list(52.135 -0.255) list(52.305 -0.255) list(52.305 -0.425)))
dbCreatePolygon(cv list("licon1" "gds_44") list(list(59.695 -0.425) list(59.695 -0.255) list(59.865 -0.255) list(59.865 -0.425)))
dbCreatePolygon(cv list("licon1" "gds_44") list(list(60.135 -0.425) list(60.135 -0.255) list(60.305 -0.255) list(60.305 -0.425)))
dbCreatePolygon(cv list("licon1" "gds_44") list(list(51.915 -0.905) list(51.915 -0.735) list(52.085 -0.735) list(52.085 -0.905)))
dbCreatePolygon(cv list("licon1" "gds_44") list(list(59.915 -0.905) list(59.915 -0.735) list(60.085 -0.735) list(60.085 -0.905)))
dbCreatePolygon(cv list("licon1" "gds_44") list(list(59.125 -0.935) list(59.125 -0.765) list(59.295 -0.765) list(59.295 -0.935)))
dbCreatePolygon(cv list("licon1" "gds_44") list(list(44.135 0.255) list(44.135 0.425) list(44.305 0.425) list(44.305 0.255)))
dbCreatePolygon(cv list("licon1" "gds_44") list(list(51.695 0.255) list(51.695 0.425) list(51.865 0.425) list(51.865 0.255)))
dbCreatePolygon(cv list("licon1" "gds_44") list(list(52.135 0.255) list(52.135 0.425) list(52.305 0.425) list(52.305 0.255)))
dbCreatePolygon(cv list("licon1" "gds_44") list(list(59.695 0.255) list(59.695 0.425) list(59.865 0.425) list(59.865 0.255)))
dbCreatePolygon(cv list("licon1" "gds_44") list(list(60.135 0.255) list(60.135 0.425) list(60.305 0.425) list(60.305 0.255)))
dbCreatePolygon(cv list("licon1" "gds_44") list(list(60.705 -0.935) list(60.705 -0.765) list(60.875 -0.765) list(60.875 -0.935)))
dbCreatePolygon(cv list("licon1" "gds_44") list(list(52.085 -1.415) list(52.085 -1.245) list(52.255 -1.245) list(52.255 -1.415)))
dbCreatePolygon(cv list("licon1" "gds_44") list(list(44.705 -0.595) list(44.705 -0.425) list(44.875 -0.425) list(44.875 -0.595)))
dbCreatePolygon(cv list("licon1" "gds_44") list(list(44.705 -0.255) list(44.705 -0.085) list(44.875 -0.085) list(44.875 -0.255)))
dbCreatePolygon(cv list("licon1" "gds_44") list(list(51.125 -0.255) list(51.125 -0.085) list(51.295 -0.085) list(51.295 -0.255)))
dbCreatePolygon(cv list("licon1" "gds_44") list(list(52.705 -0.255) list(52.705 -0.085) list(52.875 -0.085) list(52.875 -0.255)))
dbCreatePolygon(cv list("licon1" "gds_44") list(list(44.705 0.425) list(44.705 0.595) list(44.875 0.595) list(44.875 0.425)))
dbCreatePolygon(cv list("licon1" "gds_44") list(list(51.125 0.425) list(51.125 0.595) list(51.295 0.595) list(51.295 0.425)))
dbCreatePolygon(cv list("licon1" "gds_44") list(list(52.705 0.425) list(52.705 0.595) list(52.875 0.595) list(52.875 0.425)))
dbCreatePolygon(cv list("licon1" "gds_44") list(list(59.125 0.425) list(59.125 0.595) list(59.295 0.595) list(59.295 0.425)))
dbCreatePolygon(cv list("licon1" "gds_44") list(list(60.705 0.425) list(60.705 0.595) list(60.875 0.595) list(60.875 0.425)))
dbCreatePolygon(cv list("licon1" "gds_44") list(list(59.125 -0.255) list(59.125 -0.085) list(59.295 -0.085) list(59.295 -0.255)))
dbCreatePolygon(cv list("licon1" "gds_44") list(list(60.705 -0.255) list(60.705 -0.085) list(60.875 -0.085) list(60.875 -0.255)))
dbCreatePolygon(cv list("licon1" "gds_44") list(list(51.125 -0.595) list(51.125 -0.425) list(51.295 -0.425) list(51.295 -0.595)))
dbCreatePolygon(cv list("licon1" "gds_44") list(list(52.705 -0.595) list(52.705 -0.425) list(52.875 -0.425) list(52.875 -0.595)))
dbCreatePolygon(cv list("licon1" "gds_44") list(list(59.125 -0.595) list(59.125 -0.425) list(59.295 -0.425) list(59.295 -0.595)))
dbCreatePolygon(cv list("licon1" "gds_44") list(list(60.705 -0.595) list(60.705 -0.425) list(60.875 -0.425) list(60.875 -0.595)))
dbCreatePolygon(cv list("licon1" "gds_44") list(list(51.745 -1.415) list(51.745 -1.245) list(51.915 -1.245) list(51.915 -1.415)))
dbCreatePolygon(cv list("licon1" "gds_44") list(list(51.915 0.735) list(51.915 0.905) list(52.085 0.905) list(52.085 0.735)))
dbCreatePolygon(cv list("licon1" "gds_44") list(list(59.915 0.735) list(59.915 0.905) list(60.085 0.905) list(60.085 0.735)))
dbCreatePolygon(cv list("licon1" "gds_44") list(list(59.745 -1.415) list(59.745 -1.245) list(59.915 -1.245) list(59.915 -1.415)))
dbCreatePolygon(cv list("licon1" "gds_44") list(list(60.085 -1.415) list(60.085 -1.245) list(60.255 -1.245) list(60.255 -1.415)))
dbCreatePolygon(cv list("licon1" "gds_44") list(list(44.135 -0.085) list(44.135 0.085) list(44.305 0.085) list(44.305 -0.085)))
dbCreatePolygon(cv list("licon1" "gds_44") list(list(44.705 0.765) list(44.705 0.935) list(44.875 0.935) list(44.875 0.765)))
dbCreatePolygon(cv list("licon1" "gds_44") list(list(51.125 0.765) list(51.125 0.935) list(51.295 0.935) list(51.295 0.765)))
dbCreatePolygon(cv list("licon1" "gds_44") list(list(52.705 0.765) list(52.705 0.935) list(52.875 0.935) list(52.875 0.765)))
dbCreatePolygon(cv list("licon1" "gds_44") list(list(59.125 0.765) list(59.125 0.935) list(59.295 0.935) list(59.295 0.765)))
dbCreatePolygon(cv list("licon1" "gds_44") list(list(60.705 0.765) list(60.705 0.935) list(60.875 0.935) list(60.875 0.765)))
dbCreatePolygon(cv list("licon1" "gds_44") list(list(51.695 -0.085) list(51.695 0.085) list(51.865 0.085) list(51.865 -0.085)))
dbCreatePolygon(cv list("licon1" "gds_44") list(list(52.135 -0.085) list(52.135 0.085) list(52.305 0.085) list(52.305 -0.085)))
dbCreatePolygon(cv list("licon1" "gds_44") list(list(59.695 -0.085) list(59.695 0.085) list(59.865 0.085) list(59.865 -0.085)))
dbCreatePolygon(cv list("licon1" "gds_44") list(list(60.135 -0.085) list(60.135 0.085) list(60.305 0.085) list(60.305 -0.085)))
dbCreatePolygon(cv list("licon1" "gds_44") list(list(44.705 -0.935) list(44.705 -0.765) list(44.875 -0.765) list(44.875 -0.935)))
dbCreatePolygon(cv list("licon1" "gds_44") list(list(51.125 -0.935) list(51.125 -0.765) list(51.295 -0.765) list(51.295 -0.935)))
dbCreatePolygon(cv list("licon1" "gds_44") list(list(44.085 1.245) list(44.085 1.415) list(44.255 1.415) list(44.255 1.245)))
dbCreatePolygon(cv list("licon1" "gds_44") list(list(51.745 1.245) list(51.745 1.415) list(51.915 1.415) list(51.915 1.245)))
dbCreatePolygon(cv list("licon1" "gds_44") list(list(52.085 1.245) list(52.085 1.415) list(52.255 1.415) list(52.255 1.245)))
dbCreatePolygon(cv list("licon1" "gds_44") list(list(59.745 1.245) list(59.745 1.415) list(59.915 1.415) list(59.915 1.245)))
dbCreatePolygon(cv list("licon1" "gds_44") list(list(60.085 1.245) list(60.085 1.415) list(60.255 1.415) list(60.255 1.245)))
dbCreatePolygon(cv list("licon1" "gds_44") list(list(52.705 -0.935) list(52.705 -0.765) list(52.875 -0.765) list(52.875 -0.935)))
dbCreatePolygon(cv list("licon1" "gds_44") list(list(44.085 -1.415) list(44.085 -1.245) list(44.255 -1.245) list(44.255 -1.415)))
dbCreatePolygon(cv list("licon1" "gds_44") list(list(44.135 -0.425) list(44.135 -0.255) list(44.305 -0.255) list(44.305 -0.425)))
dbCreatePolygon(cv list("licon1" "gds_44") list(list(51.695 -0.425) list(51.695 -0.255) list(51.865 -0.255) list(51.865 -0.425)))
dbCreatePolygon(cv list("licon1" "gds_44") list(list(44.705 0.085) list(44.705 0.255) list(44.875 0.255) list(44.875 0.085)))
dbCreatePolygon(cv list("licon1" "gds_44") list(list(51.125 0.085) list(51.125 0.255) list(51.295 0.255) list(51.295 0.085)))
dbCreatePolygon(cv list("licon1" "gds_44") list(list(43.125 -0.255) list(43.125 -0.085) list(43.295 -0.085) list(43.295 -0.255)))
dbCreatePolygon(cv list("licon1" "gds_44") list(list(43.125 -0.935) list(43.125 -0.765) list(43.295 -0.765) list(43.295 -0.935)))
dbCreatePolygon(cv list("licon1" "gds_44") list(list(43.745 -1.415) list(43.745 -1.245) list(43.915 -1.245) list(43.915 -1.415)))
dbCreatePolygon(cv list("licon1" "gds_44") list(list(27.125 -0.085) list(27.125 0.085) list(27.295 0.085) list(27.295 -0.085)))
dbCreatePolygon(cv list("licon1" "gds_44") list(list(27.695 -0.085) list(27.695 0.085) list(27.865 0.085) list(27.865 -0.085)))
dbCreatePolygon(cv list("licon1" "gds_44") list(list(28.135 -0.085) list(28.135 0.085) list(28.305 0.085) list(28.305 -0.085)))
dbCreatePolygon(cv list("licon1" "gds_44") list(list(28.705 -0.085) list(28.705 0.085) list(28.875 0.085) list(28.875 -0.085)))
dbCreatePolygon(cv list("licon1" "gds_44") list(list(35.125 -0.085) list(35.125 0.085) list(35.295 0.085) list(35.295 -0.085)))
dbCreatePolygon(cv list("licon1" "gds_44") list(list(35.695 -0.085) list(35.695 0.085) list(35.865 0.085) list(35.865 -0.085)))
dbCreatePolygon(cv list("licon1" "gds_44") list(list(36.135 -0.085) list(36.135 0.085) list(36.305 0.085) list(36.305 -0.085)))
dbCreatePolygon(cv list("licon1" "gds_44") list(list(36.705 -0.085) list(36.705 0.085) list(36.875 0.085) list(36.875 -0.085)))
dbCreatePolygon(cv list("licon1" "gds_44") list(list(43.695 -0.085) list(43.695 0.085) list(43.865 0.085) list(43.865 -0.085)))
dbCreatePolygon(cv list("licon1" "gds_44") list(list(27.915 -0.86) list(27.915 -0.69) list(28.085 -0.69) list(28.085 -0.86)))
dbCreatePolygon(cv list("licon1" "gds_44") list(list(43.125 0.085) list(43.125 0.255) list(43.295 0.255) list(43.295 0.085)))
dbCreatePolygon(cv list("licon1" "gds_44") list(list(35.915 -0.86) list(35.915 -0.69) list(36.085 -0.69) list(36.085 -0.86)))
dbCreatePolygon(cv list("licon1" "gds_44") list(list(27.125 -0.765) list(27.125 -0.595) list(27.295 -0.595) list(27.295 -0.765)))
dbCreatePolygon(cv list("licon1" "gds_44") list(list(28.705 -0.765) list(28.705 -0.595) list(28.875 -0.595) list(28.875 -0.765)))
dbCreatePolygon(cv list("licon1" "gds_44") list(list(35.125 -0.765) list(35.125 -0.595) list(35.295 -0.595) list(35.295 -0.765)))
dbCreatePolygon(cv list("licon1" "gds_44") list(list(36.705 -0.765) list(36.705 -0.595) list(36.875 -0.595) list(36.875 -0.765)))
dbCreatePolygon(cv list("licon1" "gds_44") list(list(27.125 0.255) list(27.125 0.425) list(27.295 0.425) list(27.295 0.255)))
dbCreatePolygon(cv list("licon1" "gds_44") list(list(27.695 0.255) list(27.695 0.425) list(27.865 0.425) list(27.865 0.255)))
dbCreatePolygon(cv list("licon1" "gds_44") list(list(28.135 0.255) list(28.135 0.425) list(28.305 0.425) list(28.305 0.255)))
dbCreatePolygon(cv list("licon1" "gds_44") list(list(28.705 0.255) list(28.705 0.425) list(28.875 0.425) list(28.875 0.255)))
dbCreatePolygon(cv list("licon1" "gds_44") list(list(35.125 0.255) list(35.125 0.425) list(35.295 0.425) list(35.295 0.255)))
dbCreatePolygon(cv list("licon1" "gds_44") list(list(35.695 0.255) list(35.695 0.425) list(35.865 0.425) list(35.865 0.255)))
dbCreatePolygon(cv list("licon1" "gds_44") list(list(36.135 0.255) list(36.135 0.425) list(36.305 0.425) list(36.305 0.255)))
dbCreatePolygon(cv list("licon1" "gds_44") list(list(36.705 0.255) list(36.705 0.425) list(36.875 0.425) list(36.875 0.255)))
dbCreatePolygon(cv list("licon1" "gds_44") list(list(43.695 0.255) list(43.695 0.425) list(43.865 0.425) list(43.865 0.255)))
dbCreatePolygon(cv list("licon1" "gds_44") list(list(43.125 -0.595) list(43.125 -0.425) list(43.295 -0.425) list(43.295 -0.595)))
dbCreatePolygon(cv list("licon1" "gds_44") list(list(27.745 -1.37) list(27.745 -1.2) list(27.915 -1.2) list(27.915 -1.37)))
dbCreatePolygon(cv list("licon1" "gds_44") list(list(28.085 -1.37) list(28.085 -1.2) list(28.255 -1.2) list(28.255 -1.37)))
dbCreatePolygon(cv list("licon1" "gds_44") list(list(35.745 -1.37) list(35.745 -1.2) list(35.915 -1.2) list(35.915 -1.37)))
dbCreatePolygon(cv list("licon1" "gds_44") list(list(43.125 0.425) list(43.125 0.595) list(43.295 0.595) list(43.295 0.425)))
dbCreatePolygon(cv list("licon1" "gds_44") list(list(36.085 -1.37) list(36.085 -1.2) list(36.255 -1.2) list(36.255 -1.37)))
dbCreatePolygon(cv list("licon1" "gds_44") list(list(27.125 -0.425) list(27.125 -0.255) list(27.295 -0.255) list(27.295 -0.425)))
dbCreatePolygon(cv list("licon1" "gds_44") list(list(27.695 -0.425) list(27.695 -0.255) list(27.865 -0.255) list(27.865 -0.425)))
dbCreatePolygon(cv list("licon1" "gds_44") list(list(27.125 0.595) list(27.125 0.765) list(27.295 0.765) list(27.295 0.595)))
dbCreatePolygon(cv list("licon1" "gds_44") list(list(28.705 0.595) list(28.705 0.765) list(28.875 0.765) list(28.875 0.595)))
dbCreatePolygon(cv list("licon1" "gds_44") list(list(35.125 0.595) list(35.125 0.765) list(35.295 0.765) list(35.295 0.595)))
dbCreatePolygon(cv list("licon1" "gds_44") list(list(36.705 0.595) list(36.705 0.765) list(36.875 0.765) list(36.875 0.595)))
dbCreatePolygon(cv list("licon1" "gds_44") list(list(27.915 0.69) list(27.915 0.86) list(28.085 0.86) list(28.085 0.69)))
dbCreatePolygon(cv list("licon1" "gds_44") list(list(35.915 0.69) list(35.915 0.86) list(36.085 0.86) list(36.085 0.69)))
dbCreatePolygon(cv list("licon1" "gds_44") list(list(28.135 -0.425) list(28.135 -0.255) list(28.305 -0.255) list(28.305 -0.425)))
dbCreatePolygon(cv list("licon1" "gds_44") list(list(28.705 -0.425) list(28.705 -0.255) list(28.875 -0.255) list(28.875 -0.425)))
dbCreatePolygon(cv list("licon1" "gds_44") list(list(35.125 -0.425) list(35.125 -0.255) list(35.295 -0.255) list(35.295 -0.425)))
dbCreatePolygon(cv list("licon1" "gds_44") list(list(35.695 -0.425) list(35.695 -0.255) list(35.865 -0.255) list(35.865 -0.425)))
dbCreatePolygon(cv list("licon1" "gds_44") list(list(36.135 -0.425) list(36.135 -0.255) list(36.305 -0.255) list(36.305 -0.425)))
dbCreatePolygon(cv list("licon1" "gds_44") list(list(36.705 -0.425) list(36.705 -0.255) list(36.875 -0.255) list(36.875 -0.425)))
dbCreatePolygon(cv list("licon1" "gds_44") list(list(43.125 0.765) list(43.125 0.935) list(43.295 0.935) list(43.295 0.765)))
dbCreatePolygon(cv list("licon1" "gds_44") list(list(43.695 -0.425) list(43.695 -0.255) list(43.865 -0.255) list(43.865 -0.425)))
dbCreatePolygon(cv list("licon1" "gds_44") list(list(27.745 1.2) list(27.745 1.37) list(27.915 1.37) list(27.915 1.2)))
dbCreatePolygon(cv list("licon1" "gds_44") list(list(28.085 1.2) list(28.085 1.37) list(28.255 1.37) list(28.255 1.2)))
dbCreatePolygon(cv list("licon1" "gds_44") list(list(35.745 1.2) list(35.745 1.37) list(35.915 1.37) list(35.915 1.2)))
dbCreatePolygon(cv list("licon1" "gds_44") list(list(36.085 1.2) list(36.085 1.37) list(36.255 1.37) list(36.255 1.2)))
dbCreatePolygon(cv list("licon1" "gds_44") list(list(43.745 1.245) list(43.745 1.415) list(43.915 1.415) list(43.915 1.245)))
dbCreatePolygon(cv list("licon1" "gds_44") list(list(3.695 -0.085) list(3.695 0.085) list(3.865 0.085) list(3.865 -0.085)))
dbCreatePolygon(cv list("licon1" "gds_44") list(list(4.135 -0.085) list(4.135 0.085) list(4.305 0.085) list(4.305 -0.085)))
dbCreatePolygon(cv list("licon1" "gds_44") list(list(20.135 0.425) list(20.135 0.595) list(20.305 0.595) list(20.305 0.425)))
dbCreatePolygon(cv list("licon1" "gds_44") list(list(20.705 0.425) list(20.705 0.595) list(20.875 0.595) list(20.875 0.425)))
dbCreatePolygon(cv list("licon1" "gds_44") list(list(19.125 0.425) list(19.125 0.595) list(19.295 0.595) list(19.295 0.425)))
dbCreatePolygon(cv list("licon1" "gds_44") list(list(19.125 0.085) list(19.125 0.255) list(19.295 0.255) list(19.295 0.085)))
dbCreatePolygon(cv list("licon1" "gds_44") list(list(19.695 0.085) list(19.695 0.255) list(19.865 0.255) list(19.865 0.085)))
dbCreatePolygon(cv list("licon1" "gds_44") list(list(20.135 0.085) list(20.135 0.255) list(20.305 0.255) list(20.305 0.085)))
dbCreatePolygon(cv list("licon1" "gds_44") list(list(20.705 0.085) list(20.705 0.255) list(20.875 0.255) list(20.875 0.085)))
dbCreatePolygon(cv list("licon1" "gds_44") list(list(19.695 0.425) list(19.695 0.595) list(19.865 0.595) list(19.865 0.425)))
dbCreatePolygon(cv list("licon1" "gds_44") list(list(19.125 0.765) list(19.125 0.935) list(19.295 0.935) list(19.295 0.765)))
dbCreatePolygon(cv list("licon1" "gds_44") list(list(19.695 0.765) list(19.695 0.935) list(19.865 0.935) list(19.865 0.765)))
dbCreatePolygon(cv list("licon1" "gds_44") list(list(20.135 0.765) list(20.135 0.935) list(20.305 0.935) list(20.305 0.765)))
dbCreatePolygon(cv list("licon1" "gds_44") list(list(20.705 0.765) list(20.705 0.935) list(20.875 0.935) list(20.875 0.765)))
dbCreatePolygon(cv list("licon1" "gds_44") list(list(19.125 1.105) list(19.125 1.275) list(19.295 1.275) list(19.295 1.105)))
dbCreatePolygon(cv list("licon1" "gds_44") list(list(20.705 1.105) list(20.705 1.275) list(20.875 1.275) list(20.875 1.105)))
dbCreatePolygon(cv list("licon1" "gds_44") list(list(19.915 1.19) list(19.915 1.36) list(20.085 1.36) list(20.085 1.19)))
dbCreatePolygon(cv list("licon1" "gds_44") list(list(19.745 1.7) list(19.745 1.87) list(19.915 1.87) list(19.915 1.7)))
dbCreatePolygon(cv list("licon1" "gds_44") list(list(20.085 1.7) list(20.085 1.87) list(20.255 1.87) list(20.255 1.7)))
dbCreatePolygon(cv list("licon1" "gds_44") list(list(12.135 0.085) list(12.135 0.255) list(12.305 0.255) list(12.305 0.085)))
dbCreatePolygon(cv list("licon1" "gds_44") list(list(12.705 0.085) list(12.705 0.255) list(12.875 0.255) list(12.875 0.085)))
dbCreatePolygon(cv list("licon1" "gds_44") list(list(11.695 0.425) list(11.695 0.595) list(11.865 0.595) list(11.865 0.425)))
dbCreatePolygon(cv list("licon1" "gds_44") list(list(12.135 0.425) list(12.135 0.595) list(12.305 0.595) list(12.305 0.425)))
dbCreatePolygon(cv list("licon1" "gds_44") list(list(12.705 0.425) list(12.705 0.595) list(12.875 0.595) list(12.875 0.425)))
dbCreatePolygon(cv list("licon1" "gds_44") list(list(3.695 0.255) list(3.695 0.425) list(3.865 0.425) list(3.865 0.255)))
dbCreatePolygon(cv list("licon1" "gds_44") list(list(4.135 0.255) list(4.135 0.425) list(4.305 0.425) list(4.305 0.255)))
dbCreatePolygon(cv list("licon1" "gds_44") list(list(3.125 0.765) list(3.125 0.935) list(3.295 0.935) list(3.295 0.765)))
dbCreatePolygon(cv list("licon1" "gds_44") list(list(4.705 0.765) list(4.705 0.935) list(4.875 0.935) list(4.875 0.765)))
dbCreatePolygon(cv list("licon1" "gds_44") list(list(11.125 0.765) list(11.125 0.935) list(11.295 0.935) list(11.295 0.765)))
dbCreatePolygon(cv list("licon1" "gds_44") list(list(11.695 0.765) list(11.695 0.935) list(11.865 0.935) list(11.865 0.765)))
dbCreatePolygon(cv list("licon1" "gds_44") list(list(12.135 0.765) list(12.135 0.935) list(12.305 0.935) list(12.305 0.765)))
dbCreatePolygon(cv list("licon1" "gds_44") list(list(12.705 0.765) list(12.705 0.935) list(12.875 0.935) list(12.875 0.765)))
dbCreatePolygon(cv list("licon1" "gds_44") list(list(3.125 0.425) list(3.125 0.595) list(3.295 0.595) list(3.295 0.425)))
dbCreatePolygon(cv list("licon1" "gds_44") list(list(4.705 0.425) list(4.705 0.595) list(4.875 0.595) list(4.875 0.425)))
dbCreatePolygon(cv list("licon1" "gds_44") list(list(11.125 0.425) list(11.125 0.595) list(11.295 0.595) list(11.295 0.425)))
dbCreatePolygon(cv list("licon1" "gds_44") list(list(3.125 0.085) list(3.125 0.255) list(3.295 0.255) list(3.295 0.085)))
dbCreatePolygon(cv list("licon1" "gds_44") list(list(3.695 0.935) list(3.695 1.105) list(3.865 1.105) list(3.865 0.935)))
dbCreatePolygon(cv list("licon1" "gds_44") list(list(4.135 0.935) list(4.135 1.105) list(4.305 1.105) list(4.305 0.935)))
dbCreatePolygon(cv list("licon1" "gds_44") list(list(3.125 1.105) list(3.125 1.275) list(3.295 1.275) list(3.295 1.105)))
dbCreatePolygon(cv list("licon1" "gds_44") list(list(4.705 1.105) list(4.705 1.275) list(4.875 1.275) list(4.875 1.105)))
dbCreatePolygon(cv list("licon1" "gds_44") list(list(11.125 1.105) list(11.125 1.275) list(11.295 1.275) list(11.295 1.105)))
dbCreatePolygon(cv list("licon1" "gds_44") list(list(12.705 1.105) list(12.705 1.275) list(12.875 1.275) list(12.875 1.105)))
dbCreatePolygon(cv list("licon1" "gds_44") list(list(4.705 0.085) list(4.705 0.255) list(4.875 0.255) list(4.875 0.085)))
dbCreatePolygon(cv list("licon1" "gds_44") list(list(3.695 0.595) list(3.695 0.765) list(3.865 0.765) list(3.865 0.595)))
dbCreatePolygon(cv list("licon1" "gds_44") list(list(11.915 1.19) list(11.915 1.36) list(12.085 1.36) list(12.085 1.19)))
dbCreatePolygon(cv list("licon1" "gds_44") list(list(4.135 0.595) list(4.135 0.765) list(4.305 0.765) list(4.305 0.595)))
dbCreatePolygon(cv list("licon1" "gds_44") list(list(3.695 1.275) list(3.695 1.445) list(3.865 1.445) list(3.865 1.275)))
dbCreatePolygon(cv list("licon1" "gds_44") list(list(4.135 1.275) list(4.135 1.445) list(4.305 1.445) list(4.305 1.275)))
dbCreatePolygon(cv list("licon1" "gds_44") list(list(3.125 1.445) list(3.125 1.615) list(3.295 1.615) list(3.295 1.445)))
dbCreatePolygon(cv list("licon1" "gds_44") list(list(4.705 1.445) list(4.705 1.615) list(4.875 1.615) list(4.875 1.445)))
dbCreatePolygon(cv list("licon1" "gds_44") list(list(3.695 1.615) list(3.695 1.785) list(3.865 1.785) list(3.865 1.615)))
dbCreatePolygon(cv list("licon1" "gds_44") list(list(4.135 1.615) list(4.135 1.785) list(4.305 1.785) list(4.305 1.615)))
dbCreatePolygon(cv list("licon1" "gds_44") list(list(11.745 1.7) list(11.745 1.87) list(11.915 1.87) list(11.915 1.7)))
dbCreatePolygon(cv list("licon1" "gds_44") list(list(12.085 1.7) list(12.085 1.87) list(12.255 1.87) list(12.255 1.7)))
dbCreatePolygon(cv list("licon1" "gds_44") list(list(11.125 0.085) list(11.125 0.255) list(11.295 0.255) list(11.295 0.085)))
dbCreatePolygon(cv list("licon1" "gds_44") list(list(11.695 0.085) list(11.695 0.255) list(11.865 0.255) list(11.865 0.085)))
dbCreatePolygon(cv list("licon1" "gds_44") list(list(3.125 1.785) list(3.125 1.955) list(3.295 1.955) list(3.295 1.785)))
dbCreatePolygon(cv list("licon1" "gds_44") list(list(4.705 1.785) list(4.705 1.955) list(4.875 1.955) list(4.875 1.785)))
dbCreatePolygon(cv list("licon1" "gds_44") list(list(3.125 2.125) list(3.125 2.295) list(3.295 2.295) list(3.295 2.125)))
dbCreatePolygon(cv list("licon1" "gds_44") list(list(4.705 2.125) list(4.705 2.295) list(4.875 2.295) list(4.875 2.125)))
dbCreatePolygon(cv list("licon1" "gds_44") list(list(3.915 2.19) list(3.915 2.36) list(4.085 2.36) list(4.085 2.19)))
dbCreatePolygon(cv list("licon1" "gds_44") list(list(3.745 2.7) list(3.745 2.87) list(3.915 2.87) list(3.915 2.7)))
dbCreatePolygon(cv list("licon1" "gds_44") list(list(4.085 2.7) list(4.085 2.87) list(4.255 2.87) list(4.255 2.7)))
dbCreatePolygon(cv list("licon1" "gds_44") list(list(3.125 -0.935) list(3.125 -0.765) list(3.295 -0.765) list(3.295 -0.935)))
dbCreatePolygon(cv list("licon1" "gds_44") list(list(4.705 -0.935) list(4.705 -0.765) list(4.875 -0.765) list(4.875 -0.935)))
dbCreatePolygon(cv list("licon1" "gds_44") list(list(11.125 -0.935) list(11.125 -0.765) list(11.295 -0.765) list(11.295 -0.935)))
dbCreatePolygon(cv list("licon1" "gds_44") list(list(11.695 -0.935) list(11.695 -0.765) list(11.865 -0.765) list(11.865 -0.935)))
dbCreatePolygon(cv list("licon1" "gds_44") list(list(12.135 -0.935) list(12.135 -0.765) list(12.305 -0.765) list(12.305 -0.935)))
dbCreatePolygon(cv list("licon1" "gds_44") list(list(12.705 -0.935) list(12.705 -0.765) list(12.875 -0.765) list(12.875 -0.935)))
dbCreatePolygon(cv list("licon1" "gds_44") list(list(4.705 -1.955) list(4.705 -1.785) list(4.875 -1.785) list(4.875 -1.955)))
dbCreatePolygon(cv list("licon1" "gds_44") list(list(11.745 -1.87) list(11.745 -1.7) list(11.915 -1.7) list(11.915 -1.87)))
dbCreatePolygon(cv list("licon1" "gds_44") list(list(12.085 -1.87) list(12.085 -1.7) list(12.255 -1.7) list(12.255 -1.87)))
dbCreatePolygon(cv list("licon1" "gds_44") list(list(11.695 -0.595) list(11.695 -0.425) list(11.865 -0.425) list(11.865 -0.595)))
dbCreatePolygon(cv list("licon1" "gds_44") list(list(4.705 -1.615) list(4.705 -1.445) list(4.875 -1.445) list(4.875 -1.615)))
dbCreatePolygon(cv list("licon1" "gds_44") list(list(3.695 -1.445) list(3.695 -1.275) list(3.865 -1.275) list(3.865 -1.445)))
dbCreatePolygon(cv list("licon1" "gds_44") list(list(4.135 -1.445) list(4.135 -1.275) list(4.305 -1.275) list(4.305 -1.445)))
dbCreatePolygon(cv list("licon1" "gds_44") list(list(3.745 -2.87) list(3.745 -2.7) list(3.915 -2.7) list(3.915 -2.87)))
dbCreatePolygon(cv list("licon1" "gds_44") list(list(4.085 -2.87) list(4.085 -2.7) list(4.255 -2.7) list(4.255 -2.87)))
dbCreatePolygon(cv list("licon1" "gds_44") list(list(3.915 -2.36) list(3.915 -2.19) list(4.085 -2.19) list(4.085 -2.36)))
dbCreatePolygon(cv list("licon1" "gds_44") list(list(4.135 -1.785) list(4.135 -1.615) list(4.305 -1.615) list(4.305 -1.785)))
dbCreatePolygon(cv list("licon1" "gds_44") list(list(3.125 -1.615) list(3.125 -1.445) list(3.295 -1.445) list(3.295 -1.615)))
dbCreatePolygon(cv list("licon1" "gds_44") list(list(3.125 -0.595) list(3.125 -0.425) list(3.295 -0.425) list(3.295 -0.595)))
dbCreatePolygon(cv list("licon1" "gds_44") list(list(4.705 -0.595) list(4.705 -0.425) list(4.875 -0.425) list(4.875 -0.595)))
dbCreatePolygon(cv list("licon1" "gds_44") list(list(11.125 -0.595) list(11.125 -0.425) list(11.295 -0.425) list(11.295 -0.595)))
dbCreatePolygon(cv list("licon1" "gds_44") list(list(3.125 -0.255) list(3.125 -0.085) list(3.295 -0.085) list(3.295 -0.255)))
dbCreatePolygon(cv list("licon1" "gds_44") list(list(4.705 -0.255) list(4.705 -0.085) list(4.875 -0.085) list(4.875 -0.255)))
dbCreatePolygon(cv list("licon1" "gds_44") list(list(11.125 -0.255) list(11.125 -0.085) list(11.295 -0.085) list(11.295 -0.255)))
dbCreatePolygon(cv list("licon1" "gds_44") list(list(11.695 -0.255) list(11.695 -0.085) list(11.865 -0.085) list(11.865 -0.255)))
dbCreatePolygon(cv list("licon1" "gds_44") list(list(12.135 -0.255) list(12.135 -0.085) list(12.305 -0.085) list(12.305 -0.255)))
dbCreatePolygon(cv list("licon1" "gds_44") list(list(12.705 -0.255) list(12.705 -0.085) list(12.875 -0.085) list(12.875 -0.255)))
dbCreatePolygon(cv list("licon1" "gds_44") list(list(3.125 -2.295) list(3.125 -2.125) list(3.295 -2.125) list(3.295 -2.295)))
dbCreatePolygon(cv list("licon1" "gds_44") list(list(4.705 -2.295) list(4.705 -2.125) list(4.875 -2.125) list(4.875 -2.295)))
dbCreatePolygon(cv list("licon1" "gds_44") list(list(3.695 -0.765) list(3.695 -0.595) list(3.865 -0.595) list(3.865 -0.765)))
dbCreatePolygon(cv list("licon1" "gds_44") list(list(4.135 -0.765) list(4.135 -0.595) list(4.305 -0.595) list(4.305 -0.765)))
dbCreatePolygon(cv list("licon1" "gds_44") list(list(12.135 -0.595) list(12.135 -0.425) list(12.305 -0.425) list(12.305 -0.595)))
dbCreatePolygon(cv list("licon1" "gds_44") list(list(12.705 -0.595) list(12.705 -0.425) list(12.875 -0.425) list(12.875 -0.595)))
dbCreatePolygon(cv list("licon1" "gds_44") list(list(11.915 -1.36) list(11.915 -1.19) list(12.085 -1.19) list(12.085 -1.36)))
dbCreatePolygon(cv list("licon1" "gds_44") list(list(3.125 -1.275) list(3.125 -1.105) list(3.295 -1.105) list(3.295 -1.275)))
dbCreatePolygon(cv list("licon1" "gds_44") list(list(4.705 -1.275) list(4.705 -1.105) list(4.875 -1.105) list(4.875 -1.275)))
dbCreatePolygon(cv list("licon1" "gds_44") list(list(11.125 -1.275) list(11.125 -1.105) list(11.295 -1.105) list(11.295 -1.275)))
dbCreatePolygon(cv list("licon1" "gds_44") list(list(12.705 -1.275) list(12.705 -1.105) list(12.875 -1.105) list(12.875 -1.275)))
dbCreatePolygon(cv list("licon1" "gds_44") list(list(3.695 -0.425) list(3.695 -0.255) list(3.865 -0.255) list(3.865 -0.425)))
dbCreatePolygon(cv list("licon1" "gds_44") list(list(4.135 -0.425) list(4.135 -0.255) list(4.305 -0.255) list(4.305 -0.425)))
dbCreatePolygon(cv list("licon1" "gds_44") list(list(3.125 -1.955) list(3.125 -1.785) list(3.295 -1.785) list(3.295 -1.955)))
dbCreatePolygon(cv list("licon1" "gds_44") list(list(3.695 -1.785) list(3.695 -1.615) list(3.865 -1.615) list(3.865 -1.785)))
dbCreatePolygon(cv list("licon1" "gds_44") list(list(3.695 -1.105) list(3.695 -0.935) list(3.865 -0.935) list(3.865 -1.105)))
dbCreatePolygon(cv list("licon1" "gds_44") list(list(4.135 -1.105) list(4.135 -0.935) list(4.305 -0.935) list(4.305 -1.105)))
dbCreatePolygon(cv list("licon1" "gds_44") list(list(19.125 -0.595) list(19.125 -0.425) list(19.295 -0.425) list(19.295 -0.595)))
dbCreatePolygon(cv list("licon1" "gds_44") list(list(19.745 -1.87) list(19.745 -1.7) list(19.915 -1.7) list(19.915 -1.87)))
dbCreatePolygon(cv list("licon1" "gds_44") list(list(19.695 -0.595) list(19.695 -0.425) list(19.865 -0.425) list(19.865 -0.595)))
dbCreatePolygon(cv list("licon1" "gds_44") list(list(19.695 -0.935) list(19.695 -0.765) list(19.865 -0.765) list(19.865 -0.935)))
dbCreatePolygon(cv list("licon1" "gds_44") list(list(20.135 -0.595) list(20.135 -0.425) list(20.305 -0.425) list(20.305 -0.595)))
dbCreatePolygon(cv list("licon1" "gds_44") list(list(19.125 -1.275) list(19.125 -1.105) list(19.295 -1.105) list(19.295 -1.275)))
dbCreatePolygon(cv list("licon1" "gds_44") list(list(19.125 -0.935) list(19.125 -0.765) list(19.295 -0.765) list(19.295 -0.935)))
dbCreatePolygon(cv list("licon1" "gds_44") list(list(20.705 -1.275) list(20.705 -1.105) list(20.875 -1.105) list(20.875 -1.275)))
dbCreatePolygon(cv list("licon1" "gds_44") list(list(19.915 -1.36) list(19.915 -1.19) list(20.085 -1.19) list(20.085 -1.36)))
dbCreatePolygon(cv list("licon1" "gds_44") list(list(20.705 -0.595) list(20.705 -0.425) list(20.875 -0.425) list(20.875 -0.595)))
dbCreatePolygon(cv list("licon1" "gds_44") list(list(20.135 -0.935) list(20.135 -0.765) list(20.305 -0.765) list(20.305 -0.935)))
dbCreatePolygon(cv list("licon1" "gds_44") list(list(20.085 -1.87) list(20.085 -1.7) list(20.255 -1.7) list(20.255 -1.87)))
dbCreatePolygon(cv list("licon1" "gds_44") list(list(20.705 -0.935) list(20.705 -0.765) list(20.875 -0.765) list(20.875 -0.935)))
dbCreatePolygon(cv list("licon1" "gds_44") list(list(19.125 -0.255) list(19.125 -0.085) list(19.295 -0.085) list(19.295 -0.255)))
dbCreatePolygon(cv list("licon1" "gds_44") list(list(19.695 -0.255) list(19.695 -0.085) list(19.865 -0.085) list(19.865 -0.255)))
dbCreatePolygon(cv list("licon1" "gds_44") list(list(20.135 -0.255) list(20.135 -0.085) list(20.305 -0.085) list(20.305 -0.255)))
dbCreatePolygon(cv list("licon1" "gds_44") list(list(20.705 -0.255) list(20.705 -0.085) list(20.875 -0.085) list(20.875 -0.255)))
dbCreatePolygon(cv list("gds_95_20" "drawing") list(list(3.815 -2.46) list(3.815 -2.09) list(4.185 -2.09) list(4.185 -2.46)))
dbCreatePolygon(cv list("gds_95_20" "drawing") list(list(11.815 -1.46) list(11.815 -1.09) list(12.185 -1.09) list(12.185 -1.46)))
dbCreatePolygon(cv list("gds_95_20" "drawing") list(list(19.815 -1.46) list(19.815 -1.09) list(20.185 -1.09) list(20.185 -1.46)))
dbCreatePolygon(cv list("gds_95_20" "drawing") list(list(43.815 -1.005) list(43.815 -0.635) list(44.185 -0.635) list(44.185 -1.005)))
dbCreatePolygon(cv list("gds_95_20" "drawing") list(list(51.815 -1.005) list(51.815 -0.635) list(52.185 -0.635) list(52.185 -1.005)))
dbCreatePolygon(cv list("gds_95_20" "drawing") list(list(59.815 -1.005) list(59.815 -0.635) list(60.185 -0.635) list(60.185 -1.005)))
dbCreatePolygon(cv list("gds_95_20" "drawing") list(list(67.815 -1.005) list(67.815 -0.635) list(68.185 -0.635) list(68.185 -1.005)))
dbCreatePolygon(cv list("gds_95_20" "drawing") list(list(75.815 -1.005) list(75.815 -0.635) list(76.185 -0.635) list(76.185 -1.005)))
dbCreatePolygon(cv list("gds_95_20" "drawing") list(list(83.815 -1.005) list(83.815 -0.635) list(84.185 -0.635) list(84.185 -1.005)))
dbCreatePolygon(cv list("gds_95_20" "drawing") list(list(27.815 -0.96) list(27.815 -0.59) list(28.185 -0.59) list(28.185 -0.96)))
dbCreatePolygon(cv list("gds_95_20" "drawing") list(list(35.815 -0.96) list(35.815 -0.59) list(36.185 -0.59) list(36.185 -0.96)))
dbCreatePolygon(cv list("gds_95_20" "drawing") list(list(27.815 0.59) list(27.815 0.96) list(28.185 0.96) list(28.185 0.59)))
dbCreatePolygon(cv list("gds_95_20" "drawing") list(list(35.815 0.59) list(35.815 0.96) list(36.185 0.96) list(36.185 0.59)))
dbCreatePolygon(cv list("gds_95_20" "drawing") list(list(43.815 0.635) list(43.815 1.005) list(44.185 1.005) list(44.185 0.635)))
dbCreatePolygon(cv list("gds_95_20" "drawing") list(list(51.815 0.635) list(51.815 1.005) list(52.185 1.005) list(52.185 0.635)))
dbCreatePolygon(cv list("gds_95_20" "drawing") list(list(59.815 0.635) list(59.815 1.005) list(60.185 1.005) list(60.185 0.635)))
dbCreatePolygon(cv list("gds_95_20" "drawing") list(list(67.815 0.635) list(67.815 1.005) list(68.185 1.005) list(68.185 0.635)))
dbCreatePolygon(cv list("gds_95_20" "drawing") list(list(75.815 0.635) list(75.815 1.005) list(76.185 1.005) list(76.185 0.635)))
dbCreatePolygon(cv list("gds_95_20" "drawing") list(list(83.815 0.635) list(83.815 1.005) list(84.185 1.005) list(84.185 0.635)))
dbCreatePolygon(cv list("gds_95_20" "drawing") list(list(11.815 1.09) list(11.815 1.46) list(12.185 1.46) list(12.185 1.09)))
dbCreatePolygon(cv list("gds_95_20" "drawing") list(list(19.815 1.09) list(19.815 1.46) list(20.185 1.46) list(20.185 1.09)))
dbCreatePolygon(cv list("gds_95_20" "drawing") list(list(3.815 2.09) list(3.815 2.46) list(4.185 2.46) list(4.185 2.09)))
dbCreatePolygon(cv list("li1" "drawing") list(list(43.835 -0.905) list(43.835 -0.735) list(44.165 -0.735) list(44.165 -0.905)))
dbCreatePolygon(cv list("li1" "drawing") list(list(43.835 0.735) list(43.835 0.905) list(44.165 0.905) list(44.165 0.735)))
dbCreatePolygon(cv list("li1" "drawing") list(list(43.83 -1.5) list(43.83 -1.415) list(44.17 -1.415) list(44.17 -1.5)))
dbCreatePolygon(cv list("li1" "drawing") list(list(43.125 -1.415) list(43.125 -1.245) list(44.875 -1.245) list(44.875 -1.415)))
dbCreatePolygon(cv list("li1" "drawing") list(list(43.83 -1.245) list(43.83 -1.16) list(44.17 -1.16) list(44.17 -1.245)))
dbCreatePolygon(cv list("li1" "drawing") list(list(43.125 1.245) list(43.125 1.415) list(44.875 1.415) list(44.875 1.245)))
dbCreatePolygon(cv list("li1" "drawing") list(list(44.135 -0.52) list(44.135 0.52) list(44.305 0.52) list(44.305 -0.52)))
dbCreatePolygon(cv list("li1" "drawing") list(list(51.695 -0.52) list(51.695 0.52) list(51.865 0.52) list(51.865 -0.52)))
dbCreatePolygon(cv list("li1" "drawing") list(list(52.135 -0.52) list(52.135 0.52) list(52.305 0.52) list(52.305 -0.52)))
dbCreatePolygon(cv list("li1" "drawing") list(list(59.695 -0.52) list(59.695 0.52) list(59.865 0.52) list(59.865 -0.52)))
dbCreatePolygon(cv list("li1" "drawing") list(list(60.135 -0.52) list(60.135 0.52) list(60.305 0.52) list(60.305 -0.52)))
dbCreatePolygon(cv list("li1" "drawing") list(list(67.695 -0.52) list(67.695 0.52) list(67.865 0.52) list(67.865 -0.52)))
dbCreatePolygon(cv list("li1" "drawing") list(list(68.135 -0.52) list(68.135 0.52) list(68.305 0.52) list(68.305 -0.52)))
dbCreatePolygon(cv list("li1" "drawing") list(list(75.695 -0.52) list(75.695 0.52) list(75.865 0.52) list(75.865 -0.52)))
dbCreatePolygon(cv list("li1" "drawing") list(list(76.135 -0.52) list(76.135 0.52) list(76.305 0.52) list(76.305 -0.52)))
dbCreatePolygon(cv list("li1" "drawing") list(list(83.695 -0.52) list(83.695 0.52) list(83.865 0.52) list(83.865 -0.52)))
dbCreatePolygon(cv list("li1" "drawing") list(list(84.135 -0.52) list(84.135 0.52) list(84.305 0.52) list(84.305 -0.52)))
dbCreatePolygon(cv list("li1" "drawing") list(list(51.835 -0.905) list(51.835 -0.735) list(52.165 -0.735) list(52.165 -0.905)))
dbCreatePolygon(cv list("li1" "drawing") list(list(51.835 0.735) list(51.835 0.905) list(52.165 0.905) list(52.165 0.735)))
dbCreatePolygon(cv list("li1" "drawing") list(list(59.835 0.735) list(59.835 0.905) list(60.165 0.905) list(60.165 0.735)))
dbCreatePolygon(cv list("li1" "drawing") list(list(67.835 0.735) list(67.835 0.905) list(68.165 0.905) list(68.165 0.735)))
dbCreatePolygon(cv list("li1" "drawing") list(list(75.835 0.735) list(75.835 0.905) list(76.165 0.905) list(76.165 0.735)))
dbCreatePolygon(cv list("li1" "drawing") list(list(83.835 0.735) list(83.835 0.905) list(84.165 0.905) list(84.165 0.735)))
dbCreatePolygon(cv list("li1" "drawing") list(list(59.835 -0.905) list(59.835 -0.735) list(60.165 -0.735) list(60.165 -0.905)))
dbCreatePolygon(cv list("li1" "drawing") list(list(67.835 -0.905) list(67.835 -0.735) list(68.165 -0.735) list(68.165 -0.905)))
dbCreatePolygon(cv list("li1" "drawing") list(list(75.835 -0.905) list(75.835 -0.735) list(76.165 -0.735) list(76.165 -0.905)))
dbCreatePolygon(cv list("li1" "drawing") list(list(44.705 -1.245) list(44.705 1.245) list(44.875 1.245) list(44.875 -1.245)))
dbCreatePolygon(cv list("li1" "drawing") list(list(83.835 -0.905) list(83.835 -0.735) list(84.165 -0.735) list(84.165 -0.905)))
dbCreatePolygon(cv list("li1" "drawing") list(list(51.83 -1.5) list(51.83 -1.415) list(52.17 -1.415) list(52.17 -1.5)))
dbCreatePolygon(cv list("li1" "drawing") list(list(51.125 -1.415) list(51.125 -1.245) list(52.875 -1.245) list(52.875 -1.415)))
dbCreatePolygon(cv list("li1" "drawing") list(list(51.83 -1.245) list(51.83 -1.16) list(52.17 -1.16) list(52.17 -1.245)))
dbCreatePolygon(cv list("li1" "drawing") list(list(51.125 -1.245) list(51.125 1.245) list(51.295 1.245) list(51.295 -1.245)))
dbCreatePolygon(cv list("li1" "drawing") list(list(52.705 -1.245) list(52.705 1.245) list(52.875 1.245) list(52.875 -1.245)))
dbCreatePolygon(cv list("li1" "drawing") list(list(51.125 1.245) list(51.125 1.415) list(52.875 1.415) list(52.875 1.245)))
dbCreatePolygon(cv list("li1" "drawing") list(list(59.83 -1.5) list(59.83 -1.415) list(60.17 -1.415) list(60.17 -1.5)))
dbCreatePolygon(cv list("li1" "drawing") list(list(59.125 -1.415) list(59.125 -1.245) list(60.875 -1.245) list(60.875 -1.415)))
dbCreatePolygon(cv list("li1" "drawing") list(list(59.83 -1.245) list(59.83 -1.16) list(60.17 -1.16) list(60.17 -1.245)))
dbCreatePolygon(cv list("li1" "drawing") list(list(59.125 -1.245) list(59.125 1.245) list(59.295 1.245) list(59.295 -1.245)))
dbCreatePolygon(cv list("li1" "drawing") list(list(60.705 -1.245) list(60.705 1.245) list(60.875 1.245) list(60.875 -1.245)))
dbCreatePolygon(cv list("li1" "drawing") list(list(59.125 1.245) list(59.125 1.415) list(60.875 1.415) list(60.875 1.245)))
dbCreatePolygon(cv list("li1" "drawing") list(list(67.83 -1.5) list(67.83 -1.415) list(68.17 -1.415) list(68.17 -1.5)))
dbCreatePolygon(cv list("li1" "drawing") list(list(67.125 -1.415) list(67.125 -1.245) list(68.875 -1.245) list(68.875 -1.415)))
dbCreatePolygon(cv list("li1" "drawing") list(list(67.83 -1.245) list(67.83 -1.16) list(68.17 -1.16) list(68.17 -1.245)))
dbCreatePolygon(cv list("li1" "drawing") list(list(67.125 -1.245) list(67.125 1.245) list(67.295 1.245) list(67.295 -1.245)))
dbCreatePolygon(cv list("li1" "drawing") list(list(68.705 -1.245) list(68.705 1.245) list(68.875 1.245) list(68.875 -1.245)))
dbCreatePolygon(cv list("li1" "drawing") list(list(67.125 1.245) list(67.125 1.415) list(68.875 1.415) list(68.875 1.245)))
dbCreatePolygon(cv list("li1" "drawing") list(list(75.83 -1.5) list(75.83 -1.415) list(76.17 -1.415) list(76.17 -1.5)))
dbCreatePolygon(cv list("li1" "drawing") list(list(75.125 -1.415) list(75.125 -1.245) list(76.875 -1.245) list(76.875 -1.415)))
dbCreatePolygon(cv list("li1" "drawing") list(list(75.83 -1.245) list(75.83 -1.16) list(76.17 -1.16) list(76.17 -1.245)))
dbCreatePolygon(cv list("li1" "drawing") list(list(75.125 -1.245) list(75.125 1.245) list(75.295 1.245) list(75.295 -1.245)))
dbCreatePolygon(cv list("li1" "drawing") list(list(76.705 -1.245) list(76.705 1.245) list(76.875 1.245) list(76.875 -1.245)))
dbCreatePolygon(cv list("li1" "drawing") list(list(75.125 1.245) list(75.125 1.415) list(76.875 1.415) list(76.875 1.245)))
dbCreatePolygon(cv list("li1" "drawing") list(list(83.83 -1.5) list(83.83 -1.415) list(84.17 -1.415) list(84.17 -1.5)))
dbCreatePolygon(cv list("li1" "drawing") list(list(83.125 -1.415) list(83.125 -1.245) list(84.875 -1.245) list(84.875 -1.415)))
dbCreatePolygon(cv list("li1" "drawing") list(list(83.83 -1.245) list(83.83 -1.16) list(84.17 -1.16) list(84.17 -1.245)))
dbCreatePolygon(cv list("li1" "drawing") list(list(83.125 -1.245) list(83.125 1.245) list(83.295 1.245) list(83.295 -1.245)))
dbCreatePolygon(cv list("li1" "drawing") list(list(84.705 -1.245) list(84.705 1.245) list(84.875 1.245) list(84.875 -1.245)))
dbCreatePolygon(cv list("li1" "drawing") list(list(83.125 1.245) list(83.125 1.415) list(84.875 1.415) list(84.875 1.245)))
dbCreatePolygon(cv list("li1" "drawing") list(list(27.835 0.69) list(27.835 0.86) list(28.165 0.86) list(28.165 0.69)))
dbCreatePolygon(cv list("li1" "drawing") list(list(35.835 0.69) list(35.835 0.86) list(36.165 0.86) list(36.165 0.69)))
dbCreatePolygon(cv list("li1" "drawing") list(list(11.835 -1.36) list(11.835 -1.19) list(12.165 -1.19) list(12.165 -1.36)))
dbCreatePolygon(cv list("li1" "drawing") list(list(19.835 -1.36) list(19.835 -1.19) list(20.165 -1.19) list(20.165 -1.36)))
dbCreatePolygon(cv list("li1" "drawing") list(list(27.835 -0.86) list(27.835 -0.69) list(28.165 -0.69) list(28.165 -0.86)))
dbCreatePolygon(cv list("li1" "drawing") list(list(35.835 -0.86) list(35.835 -0.69) list(36.165 -0.69) list(36.165 -0.86)))
dbCreatePolygon(cv list("li1" "drawing") list(list(27.695 -0.52) list(27.695 0.52) list(27.865 0.52) list(27.865 -0.52)))
dbCreatePolygon(cv list("li1" "drawing") list(list(28.135 -0.52) list(28.135 0.52) list(28.305 0.52) list(28.305 -0.52)))
dbCreatePolygon(cv list("li1" "drawing") list(list(11.695 -1.02) list(11.695 1.02) list(11.865 1.02) list(11.865 -1.02)))
dbCreatePolygon(cv list("li1" "drawing") list(list(12.135 -1.02) list(12.135 1.02) list(12.305 1.02) list(12.305 -1.02)))
dbCreatePolygon(cv list("li1" "drawing") list(list(19.695 -1.02) list(19.695 1.02) list(19.865 1.02) list(19.865 -1.02)))
dbCreatePolygon(cv list("li1" "drawing") list(list(20.135 -1.02) list(20.135 1.02) list(20.305 1.02) list(20.305 -1.02)))
dbCreatePolygon(cv list("li1" "drawing") list(list(11.835 1.19) list(11.835 1.36) list(12.165 1.36) list(12.165 1.19)))
dbCreatePolygon(cv list("li1" "drawing") list(list(19.835 1.19) list(19.835 1.36) list(20.165 1.36) list(20.165 1.19)))
dbCreatePolygon(cv list("li1" "drawing") list(list(27.83 -1.455) list(27.83 -1.37) list(28.17 -1.37) list(28.17 -1.455)))
dbCreatePolygon(cv list("li1" "drawing") list(list(27.125 -1.37) list(27.125 -1.2) list(28.875 -1.2) list(28.875 -1.37)))
dbCreatePolygon(cv list("li1" "drawing") list(list(27.83 -1.2) list(27.83 -1.115) list(28.17 -1.115) list(28.17 -1.2)))
dbCreatePolygon(cv list("li1" "drawing") list(list(27.125 -1.2) list(27.125 1.2) list(27.295 1.2) list(27.295 -1.2)))
dbCreatePolygon(cv list("li1" "drawing") list(list(28.705 -1.2) list(28.705 1.2) list(28.875 1.2) list(28.875 -1.2)))
dbCreatePolygon(cv list("li1" "drawing") list(list(27.125 1.2) list(27.125 1.37) list(28.875 1.37) list(28.875 1.2)))
dbCreatePolygon(cv list("li1" "drawing") list(list(35.83 -1.455) list(35.83 -1.37) list(36.17 -1.37) list(36.17 -1.455)))
dbCreatePolygon(cv list("li1" "drawing") list(list(35.125 -1.37) list(35.125 -1.2) list(36.875 -1.2) list(36.875 -1.37)))
dbCreatePolygon(cv list("li1" "drawing") list(list(35.83 -1.2) list(35.83 -1.115) list(36.17 -1.115) list(36.17 -1.2)))
dbCreatePolygon(cv list("li1" "drawing") list(list(35.125 -1.2) list(35.125 1.2) list(35.295 1.2) list(35.295 -1.2)))
dbCreatePolygon(cv list("li1" "drawing") list(list(36.705 -1.2) list(36.705 1.2) list(36.875 1.2) list(36.875 -1.2)))
dbCreatePolygon(cv list("li1" "drawing") list(list(35.125 1.2) list(35.125 1.37) list(36.875 1.37) list(36.875 1.2)))
dbCreatePolygon(cv list("li1" "drawing") list(list(35.695 -0.52) list(35.695 0.52) list(35.865 0.52) list(35.865 -0.52)))
dbCreatePolygon(cv list("li1" "drawing") list(list(36.135 -0.52) list(36.135 0.52) list(36.305 0.52) list(36.305 -0.52)))
dbCreatePolygon(cv list("li1" "drawing") list(list(43.695 -0.52) list(43.695 0.52) list(43.865 0.52) list(43.865 -0.52)))
dbCreatePolygon(cv list("li1" "drawing") list(list(43.125 -1.245) list(43.125 1.245) list(43.295 1.245) list(43.295 -1.245)))
dbCreatePolygon(cv list("li1" "drawing") list(list(3.835 -2.36) list(3.835 -2.19) list(4.165 -2.19) list(4.165 -2.36)))
dbCreatePolygon(cv list("li1" "drawing") list(list(11.83 -1.955) list(11.83 -1.87) list(12.17 -1.87) list(12.17 -1.955)))
dbCreatePolygon(cv list("li1" "drawing") list(list(11.125 -1.87) list(11.125 -1.7) list(12.875 -1.7) list(12.875 -1.87)))
dbCreatePolygon(cv list("li1" "drawing") list(list(11.83 -1.7) list(11.83 -1.615) list(12.17 -1.615) list(12.17 -1.7)))
dbCreatePolygon(cv list("li1" "drawing") list(list(11.125 -1.7) list(11.125 1.7) list(11.295 1.7) list(11.295 -1.7)))
dbCreatePolygon(cv list("li1" "drawing") list(list(12.705 -1.7) list(12.705 1.7) list(12.875 1.7) list(12.875 -1.7)))
dbCreatePolygon(cv list("li1" "drawing") list(list(11.125 1.7) list(11.125 1.87) list(12.875 1.87) list(12.875 1.7)))
dbCreatePolygon(cv list("li1" "drawing") list(list(19.83 -1.955) list(19.83 -1.87) list(20.17 -1.87) list(20.17 -1.955)))
dbCreatePolygon(cv list("li1" "drawing") list(list(19.125 -1.87) list(19.125 -1.7) list(20.875 -1.7) list(20.875 -1.87)))
dbCreatePolygon(cv list("li1" "drawing") list(list(19.83 -1.7) list(19.83 -1.615) list(20.17 -1.615) list(20.17 -1.7)))
dbCreatePolygon(cv list("li1" "drawing") list(list(19.125 -1.7) list(19.125 1.7) list(19.295 1.7) list(19.295 -1.7)))
dbCreatePolygon(cv list("li1" "drawing") list(list(20.705 -1.7) list(20.705 1.7) list(20.875 1.7) list(20.875 -1.7)))
dbCreatePolygon(cv list("li1" "drawing") list(list(19.125 1.7) list(19.125 1.87) list(20.875 1.87) list(20.875 1.7)))
dbCreatePolygon(cv list("li1" "drawing") list(list(3.695 -2.02) list(3.695 2.02) list(3.865 2.02) list(3.865 -2.02)))
dbCreatePolygon(cv list("li1" "drawing") list(list(4.135 -2.02) list(4.135 2.02) list(4.305 2.02) list(4.305 -2.02)))
dbCreatePolygon(cv list("li1" "drawing") list(list(3.835 2.19) list(3.835 2.36) list(4.165 2.36) list(4.165 2.19)))
dbCreatePolygon(cv list("li1" "drawing") list(list(3.83 -2.955) list(3.83 -2.87) list(4.17 -2.87) list(4.17 -2.955)))
dbCreatePolygon(cv list("li1" "drawing") list(list(3.125 -2.87) list(3.125 -2.7) list(4.875 -2.7) list(4.875 -2.87)))
dbCreatePolygon(cv list("li1" "drawing") list(list(3.83 -2.7) list(3.83 -2.615) list(4.17 -2.615) list(4.17 -2.7)))
dbCreatePolygon(cv list("li1" "drawing") list(list(3.125 -2.7) list(3.125 2.7) list(3.295 2.7) list(3.295 -2.7)))
dbCreatePolygon(cv list("li1" "drawing") list(list(4.705 -2.7) list(4.705 2.7) list(4.875 2.7) list(4.875 -2.7)))
dbCreatePolygon(cv list("li1" "drawing") list(list(3.125 2.7) list(3.125 2.87) list(4.875 2.87) list(4.875 2.7)))
dbCreatePolygon(cv list("mcon" "gds_44") list(list(43.915 -1.415) list(43.915 -1.245) list(44.085 -1.245) list(44.085 -1.415)))
dbCreatePolygon(cv list("mcon" "gds_44") list(list(43.915 -0.905) list(43.915 -0.735) list(44.085 -0.735) list(44.085 -0.905)))
dbCreatePolygon(cv list("mcon" "gds_44") list(list(43.915 0.735) list(43.915 0.905) list(44.085 0.905) list(44.085 0.735)))
dbCreatePolygon(cv list("mcon" "gds_44") list(list(67.915 -1.415) list(67.915 -1.245) list(68.085 -1.245) list(68.085 -1.415)))
dbCreatePolygon(cv list("mcon" "gds_44") list(list(75.915 -1.415) list(75.915 -1.245) list(76.085 -1.245) list(76.085 -1.415)))
dbCreatePolygon(cv list("mcon" "gds_44") list(list(83.915 -1.415) list(83.915 -1.245) list(84.085 -1.245) list(84.085 -1.415)))
dbCreatePolygon(cv list("mcon" "gds_44") list(list(51.915 -1.415) list(51.915 -1.245) list(52.085 -1.245) list(52.085 -1.415)))
dbCreatePolygon(cv list("mcon" "gds_44") list(list(51.915 -0.905) list(51.915 -0.735) list(52.085 -0.735) list(52.085 -0.905)))
dbCreatePolygon(cv list("mcon" "gds_44") list(list(59.915 -0.905) list(59.915 -0.735) list(60.085 -0.735) list(60.085 -0.905)))
dbCreatePolygon(cv list("mcon" "gds_44") list(list(67.915 -0.905) list(67.915 -0.735) list(68.085 -0.735) list(68.085 -0.905)))
dbCreatePolygon(cv list("mcon" "gds_44") list(list(75.915 -0.905) list(75.915 -0.735) list(76.085 -0.735) list(76.085 -0.905)))
dbCreatePolygon(cv list("mcon" "gds_44") list(list(83.915 -0.905) list(83.915 -0.735) list(84.085 -0.735) list(84.085 -0.905)))
dbCreatePolygon(cv list("mcon" "gds_44") list(list(44.135 -0.265) list(44.135 -0.095) list(44.305 -0.095) list(44.305 -0.265)))
dbCreatePolygon(cv list("mcon" "gds_44") list(list(51.695 -0.265) list(51.695 -0.095) list(51.865 -0.095) list(51.865 -0.265)))
dbCreatePolygon(cv list("mcon" "gds_44") list(list(52.135 -0.265) list(52.135 -0.095) list(52.305 -0.095) list(52.305 -0.265)))
dbCreatePolygon(cv list("mcon" "gds_44") list(list(59.695 -0.265) list(59.695 -0.095) list(59.865 -0.095) list(59.865 -0.265)))
dbCreatePolygon(cv list("mcon" "gds_44") list(list(60.135 -0.265) list(60.135 -0.095) list(60.305 -0.095) list(60.305 -0.265)))
dbCreatePolygon(cv list("mcon" "gds_44") list(list(67.695 -0.265) list(67.695 -0.095) list(67.865 -0.095) list(67.865 -0.265)))
dbCreatePolygon(cv list("mcon" "gds_44") list(list(68.135 -0.265) list(68.135 -0.095) list(68.305 -0.095) list(68.305 -0.265)))
dbCreatePolygon(cv list("mcon" "gds_44") list(list(75.695 -0.265) list(75.695 -0.095) list(75.865 -0.095) list(75.865 -0.265)))
dbCreatePolygon(cv list("mcon" "gds_44") list(list(76.135 -0.265) list(76.135 -0.095) list(76.305 -0.095) list(76.305 -0.265)))
dbCreatePolygon(cv list("mcon" "gds_44") list(list(83.695 -0.265) list(83.695 -0.095) list(83.865 -0.095) list(83.865 -0.265)))
dbCreatePolygon(cv list("mcon" "gds_44") list(list(84.135 -0.265) list(84.135 -0.095) list(84.305 -0.095) list(84.305 -0.265)))
dbCreatePolygon(cv list("mcon" "gds_44") list(list(44.135 0.095) list(44.135 0.265) list(44.305 0.265) list(44.305 0.095)))
dbCreatePolygon(cv list("mcon" "gds_44") list(list(51.695 0.095) list(51.695 0.265) list(51.865 0.265) list(51.865 0.095)))
dbCreatePolygon(cv list("mcon" "gds_44") list(list(52.135 0.095) list(52.135 0.265) list(52.305 0.265) list(52.305 0.095)))
dbCreatePolygon(cv list("mcon" "gds_44") list(list(59.695 0.095) list(59.695 0.265) list(59.865 0.265) list(59.865 0.095)))
dbCreatePolygon(cv list("mcon" "gds_44") list(list(60.135 0.095) list(60.135 0.265) list(60.305 0.265) list(60.305 0.095)))
dbCreatePolygon(cv list("mcon" "gds_44") list(list(67.695 0.095) list(67.695 0.265) list(67.865 0.265) list(67.865 0.095)))
dbCreatePolygon(cv list("mcon" "gds_44") list(list(68.135 0.095) list(68.135 0.265) list(68.305 0.265) list(68.305 0.095)))
dbCreatePolygon(cv list("mcon" "gds_44") list(list(75.695 0.095) list(75.695 0.265) list(75.865 0.265) list(75.865 0.095)))
dbCreatePolygon(cv list("mcon" "gds_44") list(list(76.135 0.095) list(76.135 0.265) list(76.305 0.265) list(76.305 0.095)))
dbCreatePolygon(cv list("mcon" "gds_44") list(list(83.695 0.095) list(83.695 0.265) list(83.865 0.265) list(83.865 0.095)))
dbCreatePolygon(cv list("mcon" "gds_44") list(list(84.135 0.095) list(84.135 0.265) list(84.305 0.265) list(84.305 0.095)))
dbCreatePolygon(cv list("mcon" "gds_44") list(list(59.915 -1.415) list(59.915 -1.245) list(60.085 -1.245) list(60.085 -1.415)))
dbCreatePolygon(cv list("mcon" "gds_44") list(list(51.915 0.735) list(51.915 0.905) list(52.085 0.905) list(52.085 0.735)))
dbCreatePolygon(cv list("mcon" "gds_44") list(list(59.915 0.735) list(59.915 0.905) list(60.085 0.905) list(60.085 0.735)))
dbCreatePolygon(cv list("mcon" "gds_44") list(list(67.915 0.735) list(67.915 0.905) list(68.085 0.905) list(68.085 0.735)))
dbCreatePolygon(cv list("mcon" "gds_44") list(list(75.915 0.735) list(75.915 0.905) list(76.085 0.905) list(76.085 0.735)))
dbCreatePolygon(cv list("mcon" "gds_44") list(list(83.915 0.735) list(83.915 0.905) list(84.085 0.905) list(84.085 0.735)))
dbCreatePolygon(cv list("mcon" "gds_44") list(list(27.695 -0.265) list(27.695 -0.095) list(27.865 -0.095) list(27.865 -0.265)))
dbCreatePolygon(cv list("mcon" "gds_44") list(list(28.135 -0.265) list(28.135 -0.095) list(28.305 -0.095) list(28.305 -0.265)))
dbCreatePolygon(cv list("mcon" "gds_44") list(list(35.695 -0.265) list(35.695 -0.095) list(35.865 -0.095) list(35.865 -0.265)))
dbCreatePolygon(cv list("mcon" "gds_44") list(list(36.135 -0.265) list(36.135 -0.095) list(36.305 -0.095) list(36.305 -0.265)))
dbCreatePolygon(cv list("mcon" "gds_44") list(list(43.695 -0.265) list(43.695 -0.095) list(43.865 -0.095) list(43.865 -0.265)))
dbCreatePolygon(cv list("mcon" "gds_44") list(list(11.915 -1.87) list(11.915 -1.7) list(12.085 -1.7) list(12.085 -1.87)))
dbCreatePolygon(cv list("mcon" "gds_44") list(list(19.915 -1.87) list(19.915 -1.7) list(20.085 -1.7) list(20.085 -1.87)))
dbCreatePolygon(cv list("mcon" "gds_44") list(list(27.915 -1.37) list(27.915 -1.2) list(28.085 -1.2) list(28.085 -1.37)))
dbCreatePolygon(cv list("mcon" "gds_44") list(list(35.915 -1.37) list(35.915 -1.2) list(36.085 -1.2) list(36.085 -1.37)))
dbCreatePolygon(cv list("mcon" "gds_44") list(list(11.915 -1.36) list(11.915 -1.19) list(12.085 -1.19) list(12.085 -1.36)))
dbCreatePolygon(cv list("mcon" "gds_44") list(list(19.915 -1.36) list(19.915 -1.19) list(20.085 -1.19) list(20.085 -1.36)))
dbCreatePolygon(cv list("mcon" "gds_44") list(list(3.695 -1.165) list(3.695 -0.995) list(3.865 -0.995) list(3.865 -1.165)))
dbCreatePolygon(cv list("mcon" "gds_44") list(list(4.135 -1.165) list(4.135 -0.995) list(4.305 -0.995) list(4.305 -1.165)))
dbCreatePolygon(cv list("mcon" "gds_44") list(list(3.695 -1.525) list(3.695 -1.355) list(3.865 -1.355) list(3.865 -1.525)))
dbCreatePolygon(cv list("mcon" "gds_44") list(list(4.135 -1.525) list(4.135 -1.355) list(4.305 -1.355) list(4.305 -1.525)))
dbCreatePolygon(cv list("mcon" "gds_44") list(list(3.915 -2.87) list(3.915 -2.7) list(4.085 -2.7) list(4.085 -2.87)))
dbCreatePolygon(cv list("mcon" "gds_44") list(list(3.695 -0.085) list(3.695 0.085) list(3.865 0.085) list(3.865 -0.085)))
dbCreatePolygon(cv list("mcon" "gds_44") list(list(4.135 -0.085) list(4.135 0.085) list(4.305 0.085) list(4.305 -0.085)))
dbCreatePolygon(cv list("mcon" "gds_44") list(list(11.695 -0.085) list(11.695 0.085) list(11.865 0.085) list(11.865 -0.085)))
dbCreatePolygon(cv list("mcon" "gds_44") list(list(12.135 -0.085) list(12.135 0.085) list(12.305 0.085) list(12.305 -0.085)))
dbCreatePolygon(cv list("mcon" "gds_44") list(list(19.695 -0.085) list(19.695 0.085) list(19.865 0.085) list(19.865 -0.085)))
dbCreatePolygon(cv list("mcon" "gds_44") list(list(20.135 -0.085) list(20.135 0.085) list(20.305 0.085) list(20.305 -0.085)))
dbCreatePolygon(cv list("mcon" "gds_44") list(list(27.695 0.095) list(27.695 0.265) list(27.865 0.265) list(27.865 0.095)))
dbCreatePolygon(cv list("mcon" "gds_44") list(list(28.135 0.095) list(28.135 0.265) list(28.305 0.265) list(28.305 0.095)))
dbCreatePolygon(cv list("mcon" "gds_44") list(list(35.695 0.095) list(35.695 0.265) list(35.865 0.265) list(35.865 0.095)))
dbCreatePolygon(cv list("mcon" "gds_44") list(list(36.135 0.095) list(36.135 0.265) list(36.305 0.265) list(36.305 0.095)))
dbCreatePolygon(cv list("mcon" "gds_44") list(list(43.695 0.095) list(43.695 0.265) list(43.865 0.265) list(43.865 0.095)))
dbCreatePolygon(cv list("mcon" "gds_44") list(list(3.915 -2.36) list(3.915 -2.19) list(4.085 -2.19) list(4.085 -2.36)))
dbCreatePolygon(cv list("mcon" "gds_44") list(list(3.695 -1.885) list(3.695 -1.715) list(3.865 -1.715) list(3.865 -1.885)))
dbCreatePolygon(cv list("mcon" "gds_44") list(list(4.135 -1.885) list(4.135 -1.715) list(4.305 -1.715) list(4.305 -1.885)))
dbCreatePolygon(cv list("mcon" "gds_44") list(list(27.915 -0.86) list(27.915 -0.69) list(28.085 -0.69) list(28.085 -0.86)))
dbCreatePolygon(cv list("mcon" "gds_44") list(list(35.915 -0.86) list(35.915 -0.69) list(36.085 -0.69) list(36.085 -0.86)))
dbCreatePolygon(cv list("mcon" "gds_44") list(list(3.695 -0.805) list(3.695 -0.635) list(3.865 -0.635) list(3.865 -0.805)))
dbCreatePolygon(cv list("mcon" "gds_44") list(list(4.135 -0.805) list(4.135 -0.635) list(4.305 -0.635) list(4.305 -0.805)))
dbCreatePolygon(cv list("mcon" "gds_44") list(list(11.695 -0.805) list(11.695 -0.635) list(11.865 -0.635) list(11.865 -0.805)))
dbCreatePolygon(cv list("mcon" "gds_44") list(list(12.135 -0.805) list(12.135 -0.635) list(12.305 -0.635) list(12.305 -0.805)))
dbCreatePolygon(cv list("mcon" "gds_44") list(list(19.695 -0.805) list(19.695 -0.635) list(19.865 -0.635) list(19.865 -0.805)))
dbCreatePolygon(cv list("mcon" "gds_44") list(list(20.135 -0.805) list(20.135 -0.635) list(20.305 -0.635) list(20.305 -0.805)))
dbCreatePolygon(cv list("mcon" "gds_44") list(list(3.695 0.275) list(3.695 0.445) list(3.865 0.445) list(3.865 0.275)))
dbCreatePolygon(cv list("mcon" "gds_44") list(list(4.135 0.275) list(4.135 0.445) list(4.305 0.445) list(4.305 0.275)))
dbCreatePolygon(cv list("mcon" "gds_44") list(list(11.695 0.275) list(11.695 0.445) list(11.865 0.445) list(11.865 0.275)))
dbCreatePolygon(cv list("mcon" "gds_44") list(list(12.135 0.275) list(12.135 0.445) list(12.305 0.445) list(12.305 0.275)))
dbCreatePolygon(cv list("mcon" "gds_44") list(list(19.695 0.275) list(19.695 0.445) list(19.865 0.445) list(19.865 0.275)))
dbCreatePolygon(cv list("mcon" "gds_44") list(list(20.135 0.275) list(20.135 0.445) list(20.305 0.445) list(20.305 0.275)))
dbCreatePolygon(cv list("mcon" "gds_44") list(list(3.695 0.635) list(3.695 0.805) list(3.865 0.805) list(3.865 0.635)))
dbCreatePolygon(cv list("mcon" "gds_44") list(list(4.135 0.635) list(4.135 0.805) list(4.305 0.805) list(4.305 0.635)))
dbCreatePolygon(cv list("mcon" "gds_44") list(list(11.695 0.635) list(11.695 0.805) list(11.865 0.805) list(11.865 0.635)))
dbCreatePolygon(cv list("mcon" "gds_44") list(list(12.135 0.635) list(12.135 0.805) list(12.305 0.805) list(12.305 0.635)))
dbCreatePolygon(cv list("mcon" "gds_44") list(list(19.695 0.635) list(19.695 0.805) list(19.865 0.805) list(19.865 0.635)))
dbCreatePolygon(cv list("mcon" "gds_44") list(list(20.135 0.635) list(20.135 0.805) list(20.305 0.805) list(20.305 0.635)))
dbCreatePolygon(cv list("mcon" "gds_44") list(list(27.915 0.69) list(27.915 0.86) list(28.085 0.86) list(28.085 0.69)))
dbCreatePolygon(cv list("mcon" "gds_44") list(list(35.915 0.69) list(35.915 0.86) list(36.085 0.86) list(36.085 0.69)))
dbCreatePolygon(cv list("mcon" "gds_44") list(list(3.695 -0.445) list(3.695 -0.275) list(3.865 -0.275) list(3.865 -0.445)))
dbCreatePolygon(cv list("mcon" "gds_44") list(list(4.135 -0.445) list(4.135 -0.275) list(4.305 -0.275) list(4.305 -0.445)))
dbCreatePolygon(cv list("mcon" "gds_44") list(list(11.695 -0.445) list(11.695 -0.275) list(11.865 -0.275) list(11.865 -0.445)))
dbCreatePolygon(cv list("mcon" "gds_44") list(list(12.135 -0.445) list(12.135 -0.275) list(12.305 -0.275) list(12.305 -0.445)))
dbCreatePolygon(cv list("mcon" "gds_44") list(list(19.695 -0.445) list(19.695 -0.275) list(19.865 -0.275) list(19.865 -0.445)))
dbCreatePolygon(cv list("mcon" "gds_44") list(list(20.135 -0.445) list(20.135 -0.275) list(20.305 -0.275) list(20.305 -0.445)))
dbCreatePolygon(cv list("mcon" "gds_44") list(list(3.695 0.995) list(3.695 1.165) list(3.865 1.165) list(3.865 0.995)))
dbCreatePolygon(cv list("mcon" "gds_44") list(list(4.135 0.995) list(4.135 1.165) list(4.305 1.165) list(4.305 0.995)))
dbCreatePolygon(cv list("mcon" "gds_44") list(list(11.915 1.19) list(11.915 1.36) list(12.085 1.36) list(12.085 1.19)))
dbCreatePolygon(cv list("mcon" "gds_44") list(list(19.915 1.19) list(19.915 1.36) list(20.085 1.36) list(20.085 1.19)))
dbCreatePolygon(cv list("mcon" "gds_44") list(list(3.695 1.355) list(3.695 1.525) list(3.865 1.525) list(3.865 1.355)))
dbCreatePolygon(cv list("mcon" "gds_44") list(list(4.135 1.355) list(4.135 1.525) list(4.305 1.525) list(4.305 1.355)))
dbCreatePolygon(cv list("mcon" "gds_44") list(list(3.695 1.715) list(3.695 1.885) list(3.865 1.885) list(3.865 1.715)))
dbCreatePolygon(cv list("mcon" "gds_44") list(list(4.135 1.715) list(4.135 1.885) list(4.305 1.885) list(4.305 1.715)))
dbCreatePolygon(cv list("mcon" "gds_44") list(list(3.915 2.19) list(3.915 2.36) list(4.085 2.36) list(4.085 2.19)))
dbCreatePolygon(cv list("met1" "drawing") list(list(43.8 -1.53) list(43.8 -1.13) list(44.2 -1.13) list(44.2 -1.53)))
dbCreatePolygon(cv list("met1" "drawing") list(list(43.83 -0.95) list(43.83 -0.69) list(44.17 -0.69) list(44.17 -0.95)))
dbCreatePolygon(cv list("met1" "drawing") list(list(43.83 0.69) list(43.83 0.95) list(44.17 0.95) list(44.17 0.69)))
dbCreatePolygon(cv list("met1" "drawing") list(list(67.8 -1.53) list(67.8 -1.13) list(68.2 -1.13) list(68.2 -1.53)))
dbCreatePolygon(cv list("met1" "drawing") list(list(75.8 -1.53) list(75.8 -1.13) list(76.2 -1.13) list(76.2 -1.53)))
dbCreatePolygon(cv list("met1" "drawing") list(list(83.8 -1.53) list(83.8 -1.13) list(84.2 -1.13) list(84.2 -1.53)))
dbCreatePolygon(cv list("met1" "drawing") list(list(51.8 -1.53) list(51.8 -1.13) list(52.2 -1.13) list(52.2 -1.53)))
dbCreatePolygon(cv list("met1" "drawing") list(list(51.83 -0.95) list(51.83 -0.69) list(52.17 -0.69) list(52.17 -0.95)))
dbCreatePolygon(cv list("met1" "drawing") list(list(59.83 -0.95) list(59.83 -0.69) list(60.17 -0.69) list(60.17 -0.95)))
dbCreatePolygon(cv list("met1" "drawing") list(list(67.83 -0.95) list(67.83 -0.69) list(68.17 -0.69) list(68.17 -0.95)))
dbCreatePolygon(cv list("met1" "drawing") list(list(75.83 -0.95) list(75.83 -0.69) list(76.17 -0.69) list(76.17 -0.95)))
dbCreatePolygon(cv list("met1" "drawing") list(list(83.83 -0.95) list(83.83 -0.69) list(84.17 -0.69) list(84.17 -0.95)))
dbCreatePolygon(cv list("met1" "drawing") list(list(44.105 -0.5) list(44.105 -0.12) list(44.335 -0.12) list(44.335 -0.5)))
dbCreatePolygon(cv list("met1" "drawing") list(list(44.6 -0.2) list(44.6 -0.12) list(45 -0.12) list(45 -0.2)))
dbCreatePolygon(cv list("met1" "drawing") list(list(44.1 -0.12) list(44.1 0.12) list(45 0.12) list(45 -0.12)))
dbCreatePolygon(cv list("met1" "drawing") list(list(44.6 0.12) list(44.6 0.2) list(45 0.2) list(45 0.12)))
dbCreatePolygon(cv list("met1" "drawing") list(list(44.105 0.12) list(44.105 0.5) list(44.335 0.5) list(44.335 0.12)))
dbCreatePolygon(cv list("met1" "drawing") list(list(51 -0.2) list(51 -0.12) list(51.4 -0.12) list(51.4 -0.2)))
dbCreatePolygon(cv list("met1" "drawing") list(list(51.665 -0.5) list(51.665 -0.12) list(51.895 -0.12) list(51.895 -0.5)))
dbCreatePolygon(cv list("met1" "drawing") list(list(51 -0.12) list(51 0.12) list(51.9 0.12) list(51.9 -0.12)))
dbCreatePolygon(cv list("met1" "drawing") list(list(51 0.12) list(51 0.2) list(51.4 0.2) list(51.4 0.12)))
dbCreatePolygon(cv list("met1" "drawing") list(list(51.665 0.12) list(51.665 0.5) list(51.895 0.5) list(51.895 0.12)))
dbCreatePolygon(cv list("met1" "drawing") list(list(52.105 -0.5) list(52.105 -0.12) list(52.335 -0.12) list(52.335 -0.5)))
dbCreatePolygon(cv list("met1" "drawing") list(list(52.6 -0.2) list(52.6 -0.12) list(53 -0.12) list(53 -0.2)))
dbCreatePolygon(cv list("met1" "drawing") list(list(52.1 -0.12) list(52.1 0.12) list(53 0.12) list(53 -0.12)))
dbCreatePolygon(cv list("met1" "drawing") list(list(52.6 0.12) list(52.6 0.2) list(53 0.2) list(53 0.12)))
dbCreatePolygon(cv list("met1" "drawing") list(list(52.105 0.12) list(52.105 0.5) list(52.335 0.5) list(52.335 0.12)))
dbCreatePolygon(cv list("met1" "drawing") list(list(59 -0.2) list(59 -0.12) list(59.4 -0.12) list(59.4 -0.2)))
dbCreatePolygon(cv list("met1" "drawing") list(list(59.665 -0.5) list(59.665 -0.12) list(59.895 -0.12) list(59.895 -0.5)))
dbCreatePolygon(cv list("met1" "drawing") list(list(59 -0.12) list(59 0.12) list(59.9 0.12) list(59.9 -0.12)))
dbCreatePolygon(cv list("met1" "drawing") list(list(59 0.12) list(59 0.2) list(59.4 0.2) list(59.4 0.12)))
dbCreatePolygon(cv list("met1" "drawing") list(list(59.665 0.12) list(59.665 0.5) list(59.895 0.5) list(59.895 0.12)))
dbCreatePolygon(cv list("met1" "drawing") list(list(60.105 -0.5) list(60.105 -0.12) list(60.335 -0.12) list(60.335 -0.5)))
dbCreatePolygon(cv list("met1" "drawing") list(list(60.6 -0.2) list(60.6 -0.12) list(61 -0.12) list(61 -0.2)))
dbCreatePolygon(cv list("met1" "drawing") list(list(60.1 -0.12) list(60.1 0.12) list(61 0.12) list(61 -0.12)))
dbCreatePolygon(cv list("met1" "drawing") list(list(60.6 0.12) list(60.6 0.2) list(61 0.2) list(61 0.12)))
dbCreatePolygon(cv list("met1" "drawing") list(list(60.105 0.12) list(60.105 0.5) list(60.335 0.5) list(60.335 0.12)))
dbCreatePolygon(cv list("met1" "drawing") list(list(67 -0.2) list(67 -0.12) list(67.4 -0.12) list(67.4 -0.2)))
dbCreatePolygon(cv list("met1" "drawing") list(list(67.665 -0.5) list(67.665 -0.12) list(67.895 -0.12) list(67.895 -0.5)))
dbCreatePolygon(cv list("met1" "drawing") list(list(67 -0.12) list(67 0.12) list(67.9 0.12) list(67.9 -0.12)))
dbCreatePolygon(cv list("met1" "drawing") list(list(67 0.12) list(67 0.2) list(67.4 0.2) list(67.4 0.12)))
dbCreatePolygon(cv list("met1" "drawing") list(list(67.665 0.12) list(67.665 0.5) list(67.895 0.5) list(67.895 0.12)))
dbCreatePolygon(cv list("met1" "drawing") list(list(68.105 -0.5) list(68.105 -0.12) list(68.335 -0.12) list(68.335 -0.5)))
dbCreatePolygon(cv list("met1" "drawing") list(list(68.6 -0.2) list(68.6 -0.12) list(69 -0.12) list(69 -0.2)))
dbCreatePolygon(cv list("met1" "drawing") list(list(68.1 -0.12) list(68.1 0.12) list(69 0.12) list(69 -0.12)))
dbCreatePolygon(cv list("met1" "drawing") list(list(68.6 0.12) list(68.6 0.2) list(69 0.2) list(69 0.12)))
dbCreatePolygon(cv list("met1" "drawing") list(list(68.105 0.12) list(68.105 0.5) list(68.335 0.5) list(68.335 0.12)))
dbCreatePolygon(cv list("met1" "drawing") list(list(75 -0.2) list(75 -0.12) list(75.4 -0.12) list(75.4 -0.2)))
dbCreatePolygon(cv list("met1" "drawing") list(list(75.665 -0.5) list(75.665 -0.12) list(75.895 -0.12) list(75.895 -0.5)))
dbCreatePolygon(cv list("met1" "drawing") list(list(75 -0.12) list(75 0.12) list(75.9 0.12) list(75.9 -0.12)))
dbCreatePolygon(cv list("met1" "drawing") list(list(75 0.12) list(75 0.2) list(75.4 0.2) list(75.4 0.12)))
dbCreatePolygon(cv list("met1" "drawing") list(list(75.665 0.12) list(75.665 0.5) list(75.895 0.5) list(75.895 0.12)))
dbCreatePolygon(cv list("met1" "drawing") list(list(76.105 -0.5) list(76.105 -0.12) list(76.335 -0.12) list(76.335 -0.5)))
dbCreatePolygon(cv list("met1" "drawing") list(list(76.6 -0.2) list(76.6 -0.12) list(77 -0.12) list(77 -0.2)))
dbCreatePolygon(cv list("met1" "drawing") list(list(76.1 -0.12) list(76.1 0.12) list(77 0.12) list(77 -0.12)))
dbCreatePolygon(cv list("met1" "drawing") list(list(76.6 0.12) list(76.6 0.2) list(77 0.2) list(77 0.12)))
dbCreatePolygon(cv list("met1" "drawing") list(list(76.105 0.12) list(76.105 0.5) list(76.335 0.5) list(76.335 0.12)))
dbCreatePolygon(cv list("met1" "drawing") list(list(83 -0.2) list(83 -0.12) list(83.4 -0.12) list(83.4 -0.2)))
dbCreatePolygon(cv list("met1" "drawing") list(list(83.665 -0.5) list(83.665 -0.12) list(83.895 -0.12) list(83.895 -0.5)))
dbCreatePolygon(cv list("met1" "drawing") list(list(83 -0.12) list(83 0.12) list(83.9 0.12) list(83.9 -0.12)))
dbCreatePolygon(cv list("met1" "drawing") list(list(83 0.12) list(83 0.2) list(83.4 0.2) list(83.4 0.12)))
dbCreatePolygon(cv list("met1" "drawing") list(list(83.665 0.12) list(83.665 0.5) list(83.895 0.5) list(83.895 0.12)))
dbCreatePolygon(cv list("met1" "drawing") list(list(84.105 -0.5) list(84.105 -0.12) list(84.335 -0.12) list(84.335 -0.5)))
dbCreatePolygon(cv list("met1" "drawing") list(list(84.6 -0.2) list(84.6 -0.12) list(85 -0.12) list(85 -0.2)))
dbCreatePolygon(cv list("met1" "drawing") list(list(84.1 -0.12) list(84.1 0.12) list(85 0.12) list(85 -0.12)))
dbCreatePolygon(cv list("met1" "drawing") list(list(84.6 0.12) list(84.6 0.2) list(85 0.2) list(85 0.12)))
dbCreatePolygon(cv list("met1" "drawing") list(list(84.105 0.12) list(84.105 0.5) list(84.335 0.5) list(84.335 0.12)))
dbCreatePolygon(cv list("met1" "drawing") list(list(59.8 -1.53) list(59.8 -1.13) list(60.2 -1.13) list(60.2 -1.53)))
dbCreatePolygon(cv list("met1" "drawing") list(list(51.83 0.69) list(51.83 0.95) list(52.17 0.95) list(52.17 0.69)))
dbCreatePolygon(cv list("met1" "drawing") list(list(59.83 0.69) list(59.83 0.95) list(60.17 0.95) list(60.17 0.69)))
dbCreatePolygon(cv list("met1" "drawing") list(list(67.83 0.69) list(67.83 0.95) list(68.17 0.95) list(68.17 0.69)))
dbCreatePolygon(cv list("met1" "drawing") list(list(75.83 0.69) list(75.83 0.95) list(76.17 0.95) list(76.17 0.69)))
dbCreatePolygon(cv list("met1" "drawing") list(list(83.83 0.69) list(83.83 0.95) list(84.17 0.95) list(84.17 0.69)))
dbCreatePolygon(cv list("met1" "drawing") list(list(36.6 -0.2) list(36.6 -0.12) list(37 -0.12) list(37 -0.2)))
dbCreatePolygon(cv list("met1" "drawing") list(list(36.1 -0.12) list(36.1 0.12) list(37 0.12) list(37 -0.12)))
dbCreatePolygon(cv list("met1" "drawing") list(list(36.6 0.12) list(36.6 0.2) list(37 0.2) list(37 0.12)))
dbCreatePolygon(cv list("met1" "drawing") list(list(36.105 0.12) list(36.105 0.5) list(36.335 0.5) list(36.335 0.12)))
dbCreatePolygon(cv list("met1" "drawing") list(list(43 -0.2) list(43 -0.12) list(43.4 -0.12) list(43.4 -0.2)))
dbCreatePolygon(cv list("met1" "drawing") list(list(43.665 -0.5) list(43.665 -0.12) list(43.895 -0.12) list(43.895 -0.5)))
dbCreatePolygon(cv list("met1" "drawing") list(list(43 -0.12) list(43 0.12) list(43.9 0.12) list(43.9 -0.12)))
dbCreatePolygon(cv list("met1" "drawing") list(list(43 0.12) list(43 0.2) list(43.4 0.2) list(43.4 0.12)))
dbCreatePolygon(cv list("met1" "drawing") list(list(43.665 0.12) list(43.665 0.5) list(43.895 0.5) list(43.895 0.12)))
dbCreatePolygon(cv list("met1" "drawing") list(list(27.8 -1.485) list(27.8 -1.085) list(28.2 -1.085) list(28.2 -1.485)))
dbCreatePolygon(cv list("met1" "drawing") list(list(35.8 -1.485) list(35.8 -1.085) list(36.2 -1.085) list(36.2 -1.485)))
dbCreatePolygon(cv list("met1" "drawing") list(list(3.8 -2.985) list(3.8 -2.585) list(4.2 -2.585) list(4.2 -2.985)))
dbCreatePolygon(cv list("met1" "drawing") list(list(3.83 -2.405) list(3.83 -2.145) list(4.17 -2.145) list(4.17 -2.405)))
dbCreatePolygon(cv list("met1" "drawing") list(list(11.8 -1.985) list(11.8 -1.585) list(12.2 -1.585) list(12.2 -1.985)))
dbCreatePolygon(cv list("met1" "drawing") list(list(19.8 -1.985) list(19.8 -1.585) list(20.2 -1.585) list(20.2 -1.985)))
dbCreatePolygon(cv list("met1" "drawing") list(list(11.83 -1.405) list(11.83 -1.145) list(12.17 -1.145) list(12.17 -1.405)))
dbCreatePolygon(cv list("met1" "drawing") list(list(19.83 -1.405) list(19.83 -1.145) list(20.17 -1.145) list(20.17 -1.405)))
dbCreatePolygon(cv list("met1" "drawing") list(list(27.83 -0.905) list(27.83 -0.645) list(28.17 -0.645) list(28.17 -0.905)))
dbCreatePolygon(cv list("met1" "drawing") list(list(35.83 -0.905) list(35.83 -0.645) list(36.17 -0.645) list(36.17 -0.905)))
dbCreatePolygon(cv list("met1" "drawing") list(list(27 -0.2) list(27 -0.12) list(27.4 -0.12) list(27.4 -0.2)))
dbCreatePolygon(cv list("met1" "drawing") list(list(27.665 -0.5) list(27.665 -0.12) list(27.895 -0.12) list(27.895 -0.5)))
dbCreatePolygon(cv list("met1" "drawing") list(list(27 -0.12) list(27 0.12) list(27.9 0.12) list(27.9 -0.12)))
dbCreatePolygon(cv list("met1" "drawing") list(list(27 0.12) list(27 0.2) list(27.4 0.2) list(27.4 0.12)))
dbCreatePolygon(cv list("met1" "drawing") list(list(27.665 0.12) list(27.665 0.5) list(27.895 0.5) list(27.895 0.12)))
dbCreatePolygon(cv list("met1" "drawing") list(list(28.105 -0.5) list(28.105 -0.12) list(28.335 -0.12) list(28.335 -0.5)))
dbCreatePolygon(cv list("met1" "drawing") list(list(28.6 -0.2) list(28.6 -0.12) list(29 -0.12) list(29 -0.2)))
dbCreatePolygon(cv list("met1" "drawing") list(list(28.1 -0.12) list(28.1 0.12) list(29 0.12) list(29 -0.12)))
dbCreatePolygon(cv list("met1" "drawing") list(list(28.6 0.12) list(28.6 0.2) list(29 0.2) list(29 0.12)))
dbCreatePolygon(cv list("met1" "drawing") list(list(28.105 0.12) list(28.105 0.5) list(28.335 0.5) list(28.335 0.12)))
dbCreatePolygon(cv list("met1" "drawing") list(list(27.83 0.645) list(27.83 0.905) list(28.17 0.905) list(28.17 0.645)))
dbCreatePolygon(cv list("met1" "drawing") list(list(35.83 0.645) list(35.83 0.905) list(36.17 0.905) list(36.17 0.645)))
dbCreatePolygon(cv list("met1" "drawing") list(list(35 -0.2) list(35 -0.12) list(35.4 -0.12) list(35.4 -0.2)))
dbCreatePolygon(cv list("met1" "drawing") list(list(35.665 -0.5) list(35.665 -0.12) list(35.895 -0.12) list(35.895 -0.5)))
dbCreatePolygon(cv list("met1" "drawing") list(list(35 -0.12) list(35 0.12) list(35.9 0.12) list(35.9 -0.12)))
dbCreatePolygon(cv list("met1" "drawing") list(list(35 0.12) list(35 0.2) list(35.4 0.2) list(35.4 0.12)))
dbCreatePolygon(cv list("met1" "drawing") list(list(35.665 0.12) list(35.665 0.5) list(35.895 0.5) list(35.895 0.12)))
dbCreatePolygon(cv list("met1" "drawing") list(list(36.105 -0.5) list(36.105 -0.12) list(36.335 -0.12) list(36.335 -0.5)))
dbCreatePolygon(cv list("met1" "drawing") list(list(11 -0.2) list(11 -0.12) list(11.4 -0.12) list(11.4 -0.2)))
dbCreatePolygon(cv list("met1" "drawing") list(list(11.665 -1) list(11.665 -0.12) list(11.895 -0.12) list(11.895 -1)))
dbCreatePolygon(cv list("met1" "drawing") list(list(11 -0.12) list(11 0.12) list(11.9 0.12) list(11.9 -0.12)))
dbCreatePolygon(cv list("met1" "drawing") list(list(11 0.12) list(11 0.2) list(11.4 0.2) list(11.4 0.12)))
dbCreatePolygon(cv list("met1" "drawing") list(list(11.665 0.12) list(11.665 1) list(11.895 1) list(11.895 0.12)))
dbCreatePolygon(cv list("met1" "drawing") list(list(12.105 -1) list(12.105 -0.12) list(12.335 -0.12) list(12.335 -1)))
dbCreatePolygon(cv list("met1" "drawing") list(list(12.6 -0.2) list(12.6 -0.12) list(13 -0.12) list(13 -0.2)))
dbCreatePolygon(cv list("met1" "drawing") list(list(12.1 -0.12) list(12.1 0.12) list(13 0.12) list(13 -0.12)))
dbCreatePolygon(cv list("met1" "drawing") list(list(12.6 0.12) list(12.6 0.2) list(13 0.2) list(13 0.12)))
dbCreatePolygon(cv list("met1" "drawing") list(list(12.105 0.12) list(12.105 1) list(12.335 1) list(12.335 0.12)))
dbCreatePolygon(cv list("met1" "drawing") list(list(19 -0.2) list(19 -0.12) list(19.4 -0.12) list(19.4 -0.2)))
dbCreatePolygon(cv list("met1" "drawing") list(list(19.665 -1) list(19.665 -0.12) list(19.895 -0.12) list(19.895 -1)))
dbCreatePolygon(cv list("met1" "drawing") list(list(19 -0.12) list(19 0.12) list(19.9 0.12) list(19.9 -0.12)))
dbCreatePolygon(cv list("met1" "drawing") list(list(19 0.12) list(19 0.2) list(19.4 0.2) list(19.4 0.12)))
dbCreatePolygon(cv list("met1" "drawing") list(list(19.665 0.12) list(19.665 1) list(19.895 1) list(19.895 0.12)))
dbCreatePolygon(cv list("met1" "drawing") list(list(20.105 -1) list(20.105 -0.12) list(20.335 -0.12) list(20.335 -1)))
dbCreatePolygon(cv list("met1" "drawing") list(list(20.6 -0.2) list(20.6 -0.12) list(21 -0.12) list(21 -0.2)))
dbCreatePolygon(cv list("met1" "drawing") list(list(20.1 -0.12) list(20.1 0.12) list(21 0.12) list(21 -0.12)))
dbCreatePolygon(cv list("met1" "drawing") list(list(20.6 0.12) list(20.6 0.2) list(21 0.2) list(21 0.12)))
dbCreatePolygon(cv list("met1" "drawing") list(list(20.105 0.12) list(20.105 1) list(20.335 1) list(20.335 0.12)))
dbCreatePolygon(cv list("met1" "drawing") list(list(11.83 1.145) list(11.83 1.405) list(12.17 1.405) list(12.17 1.145)))
dbCreatePolygon(cv list("met1" "drawing") list(list(19.83 1.145) list(19.83 1.405) list(20.17 1.405) list(20.17 1.145)))
dbCreatePolygon(cv list("met1" "drawing") list(list(3 -0.2) list(3 -0.12) list(3.4 -0.12) list(3.4 -0.2)))
dbCreatePolygon(cv list("met1" "drawing") list(list(3.665 -2) list(3.665 -0.12) list(3.895 -0.12) list(3.895 -2)))
dbCreatePolygon(cv list("met1" "drawing") list(list(3 -0.12) list(3 0.12) list(3.9 0.12) list(3.9 -0.12)))
dbCreatePolygon(cv list("met1" "drawing") list(list(3 0.12) list(3 0.2) list(3.4 0.2) list(3.4 0.12)))
dbCreatePolygon(cv list("met1" "drawing") list(list(3.665 0.12) list(3.665 2) list(3.895 2) list(3.895 0.12)))
dbCreatePolygon(cv list("met1" "drawing") list(list(4.105 -2) list(4.105 -0.12) list(4.335 -0.12) list(4.335 -2)))
dbCreatePolygon(cv list("met1" "drawing") list(list(4.6 -0.2) list(4.6 -0.12) list(5 -0.12) list(5 -0.2)))
dbCreatePolygon(cv list("met1" "drawing") list(list(4.1 -0.12) list(4.1 0.12) list(5 0.12) list(5 -0.12)))
dbCreatePolygon(cv list("met1" "drawing") list(list(4.6 0.12) list(4.6 0.2) list(5 0.2) list(5 0.12)))
dbCreatePolygon(cv list("met1" "drawing") list(list(4.105 0.12) list(4.105 2) list(4.335 2) list(4.335 0.12)))
dbCreatePolygon(cv list("met1" "drawing") list(list(3.83 2.145) list(3.83 2.405) list(4.17 2.405) list(4.17 2.145)))
dbCreatePolygon(cv list("nwell" "drawing") list(list(42.945 -1.595) list(42.945 1.595) list(45.055 1.595) list(45.055 -1.595)))
dbCreatePolygon(cv list("nwell" "drawing") list(list(50.945 -1.595) list(50.945 1.595) list(53.055 1.595) list(53.055 -1.595)))
dbCreatePolygon(cv list("nwell" "drawing") list(list(58.945 -1.595) list(58.945 1.595) list(61.055 1.595) list(61.055 -1.595)))
dbCreatePolygon(cv list("nwell" "drawing") list(list(66.945 -1.595) list(66.945 1.595) list(69.055 1.595) list(69.055 -1.595)))
dbCreatePolygon(cv list("nwell" "drawing") list(list(74.945 -1.595) list(74.945 1.595) list(77.055 1.595) list(77.055 -1.595)))
dbCreatePolygon(cv list("nwell" "drawing") list(list(82.945 -1.595) list(82.945 1.595) list(85.055 1.595) list(85.055 -1.595)))
dbCreatePolygon(cv list("via" "gds_44") list(list(3.925 -2.86) list(3.925 -2.71) list(4.075 -2.71) list(4.075 -2.86)))
dbCreatePolygon(cv list("via" "gds_44") list(list(11.925 -1.86) list(11.925 -1.71) list(12.075 -1.71) list(12.075 -1.86)))
dbCreatePolygon(cv list("via" "gds_44") list(list(19.925 -1.86) list(19.925 -1.71) list(20.075 -1.71) list(20.075 -1.86)))
dbCreatePolygon(cv list("via" "gds_44") list(list(43.925 -1.405) list(43.925 -1.255) list(44.075 -1.255) list(44.075 -1.405)))
dbCreatePolygon(cv list("via" "gds_44") list(list(51.925 -1.405) list(51.925 -1.255) list(52.075 -1.255) list(52.075 -1.405)))
dbCreatePolygon(cv list("via" "gds_44") list(list(59.925 -1.405) list(59.925 -1.255) list(60.075 -1.255) list(60.075 -1.405)))
dbCreatePolygon(cv list("via" "gds_44") list(list(67.925 -1.405) list(67.925 -1.255) list(68.075 -1.255) list(68.075 -1.405)))
dbCreatePolygon(cv list("via" "gds_44") list(list(75.925 -1.405) list(75.925 -1.255) list(76.075 -1.255) list(76.075 -1.405)))
dbCreatePolygon(cv list("via" "gds_44") list(list(83.925 -1.405) list(83.925 -1.255) list(84.075 -1.255) list(84.075 -1.405)))
dbCreatePolygon(cv list("via" "gds_44") list(list(27.925 -1.36) list(27.925 -1.21) list(28.075 -1.21) list(28.075 -1.36)))
dbCreatePolygon(cv list("via" "gds_44") list(list(35.925 -1.36) list(35.925 -1.21) list(36.075 -1.21) list(36.075 -1.36)))
dbCreatePolygon(cv list("via" "gds_44") list(list(3.125 -0.075) list(3.125 0.075) list(3.275 0.075) list(3.275 -0.075)))
dbCreatePolygon(cv list("via" "gds_44") list(list(4.725 -0.075) list(4.725 0.075) list(4.875 0.075) list(4.875 -0.075)))
dbCreatePolygon(cv list("via" "gds_44") list(list(11.125 -0.075) list(11.125 0.075) list(11.275 0.075) list(11.275 -0.075)))
dbCreatePolygon(cv list("via" "gds_44") list(list(12.725 -0.075) list(12.725 0.075) list(12.875 0.075) list(12.875 -0.075)))
dbCreatePolygon(cv list("via" "gds_44") list(list(19.125 -0.075) list(19.125 0.075) list(19.275 0.075) list(19.275 -0.075)))
dbCreatePolygon(cv list("via" "gds_44") list(list(20.725 -0.075) list(20.725 0.075) list(20.875 0.075) list(20.875 -0.075)))
dbCreatePolygon(cv list("via" "gds_44") list(list(27.125 -0.075) list(27.125 0.075) list(27.275 0.075) list(27.275 -0.075)))
dbCreatePolygon(cv list("via" "gds_44") list(list(28.725 -0.075) list(28.725 0.075) list(28.875 0.075) list(28.875 -0.075)))
dbCreatePolygon(cv list("via" "gds_44") list(list(35.125 -0.075) list(35.125 0.075) list(35.275 0.075) list(35.275 -0.075)))
dbCreatePolygon(cv list("via" "gds_44") list(list(36.725 -0.075) list(36.725 0.075) list(36.875 0.075) list(36.875 -0.075)))
dbCreatePolygon(cv list("via" "gds_44") list(list(43.125 -0.075) list(43.125 0.075) list(43.275 0.075) list(43.275 -0.075)))
dbCreatePolygon(cv list("via" "gds_44") list(list(44.725 -0.075) list(44.725 0.075) list(44.875 0.075) list(44.875 -0.075)))
dbCreatePolygon(cv list("via" "gds_44") list(list(51.125 -0.075) list(51.125 0.075) list(51.275 0.075) list(51.275 -0.075)))
dbCreatePolygon(cv list("via" "gds_44") list(list(52.725 -0.075) list(52.725 0.075) list(52.875 0.075) list(52.875 -0.075)))
dbCreatePolygon(cv list("via" "gds_44") list(list(59.125 -0.075) list(59.125 0.075) list(59.275 0.075) list(59.275 -0.075)))
dbCreatePolygon(cv list("via" "gds_44") list(list(60.725 -0.075) list(60.725 0.075) list(60.875 0.075) list(60.875 -0.075)))
dbCreatePolygon(cv list("via" "gds_44") list(list(67.125 -0.075) list(67.125 0.075) list(67.275 0.075) list(67.275 -0.075)))
dbCreatePolygon(cv list("via" "gds_44") list(list(68.725 -0.075) list(68.725 0.075) list(68.875 0.075) list(68.875 -0.075)))
dbCreatePolygon(cv list("via" "gds_44") list(list(75.125 -0.075) list(75.125 0.075) list(75.275 0.075) list(75.275 -0.075)))
dbCreatePolygon(cv list("via" "gds_44") list(list(76.725 -0.075) list(76.725 0.075) list(76.875 0.075) list(76.875 -0.075)))
dbCreatePolygon(cv list("via" "gds_44") list(list(83.125 -0.075) list(83.125 0.075) list(83.275 0.075) list(83.275 -0.075)))
dbCreatePolygon(cv list("via" "gds_44") list(list(84.725 -0.075) list(84.725 0.075) list(84.875 0.075) list(84.875 -0.075)))
dbCreatePolygon(cv list("via" "gds_44") list(list(27.925 0.7) list(27.925 0.85) list(28.075 0.85) list(28.075 0.7)))
dbCreatePolygon(cv list("via" "gds_44") list(list(35.925 0.7) list(35.925 0.85) list(36.075 0.85) list(36.075 0.7)))
dbCreatePolygon(cv list("via" "gds_44") list(list(43.925 0.745) list(43.925 0.895) list(44.075 0.895) list(44.075 0.745)))
dbCreatePolygon(cv list("via" "gds_44") list(list(51.925 0.745) list(51.925 0.895) list(52.075 0.895) list(52.075 0.745)))
dbCreatePolygon(cv list("via" "gds_44") list(list(59.925 0.745) list(59.925 0.895) list(60.075 0.895) list(60.075 0.745)))
dbCreatePolygon(cv list("via" "gds_44") list(list(67.925 0.745) list(67.925 0.895) list(68.075 0.895) list(68.075 0.745)))
dbCreatePolygon(cv list("via" "gds_44") list(list(75.925 0.745) list(75.925 0.895) list(76.075 0.895) list(76.075 0.745)))
dbCreatePolygon(cv list("via" "gds_44") list(list(83.925 0.745) list(83.925 0.895) list(84.075 0.895) list(84.075 0.745)))
dbCreatePolygon(cv list("via" "gds_44") list(list(11.925 1.2) list(11.925 1.35) list(12.075 1.35) list(12.075 1.2)))
dbCreatePolygon(cv list("via" "gds_44") list(list(19.925 1.2) list(19.925 1.35) list(20.075 1.35) list(20.075 1.2)))
dbCreatePolygon(cv list("via" "gds_44") list(list(3.925 2.2) list(3.925 2.35) list(4.075 2.35) list(4.075 2.2)))
dbCreatePolygon(cv list("met2" "drawing") list(list(11.8 1.075) list(11.8 10.2) list(12.2 10.2) list(12.2 1.075)))
dbCreatePolygon(cv list("met2" "drawing") list(list(19.8 1.075) list(19.8 11.4) list(20.2 11.4) list(20.2 1.075)))
dbCreatePolygon(cv list("met2" "drawing") list(list(3.8 2.075) list(3.8 12.6) list(4.2 12.6) list(4.2 2.075)))
dbCreatePolygon(cv list("met2" "drawing") list(list(59.8 0.62) list(59.8 12.6) list(60.2 12.6) list(60.2 0.62)))
dbCreatePolygon(cv list("met2" "drawing") list(list(67.8 0.62) list(67.8 12.6) list(68.2 12.6) list(68.2 0.62)))
dbCreatePolygon(cv list("met2" "drawing") list(list(75.8 0.62) list(75.8 12.6) list(76.2 12.6) list(76.2 0.62)))
dbCreatePolygon(cv list("met2" "drawing") list(list(83.8 0.62) list(83.8 12.6) list(84.2 12.6) list(84.2 0.62)))
dbCreatePolygon(cv list("met2" "drawing") list(list(27 -0.2) list(27 13.8) list(27.4 13.8) list(27.4 -0.2)))
dbCreatePolygon(cv list("met2" "drawing") list(list(35.8 0.575) list(35.8 13.8) list(36.2 13.8) list(36.2 0.575)))
dbCreatePolygon(cv list("met2" "drawing") list(list(43 -0.2) list(43 13.8) list(43.4 13.8) list(43.4 -0.2)))
dbCreatePolygon(cv list("met2" "drawing") list(list(51.8 0.62) list(51.8 13.8) list(52.2 13.8) list(52.2 0.62)))
dbCreatePolygon(cv list("met2" "drawing") list(list(75 -0.2) list(75 13.8) list(75.4 13.8) list(75.4 -0.2)))
dbCreatePolygon(cv list("met2" "drawing") list(list(27.8 0.575) list(27.8 15) list(28.2 15) list(28.2 0.575)))
dbCreatePolygon(cv list("met2" "drawing") list(list(35 -0.2) list(35 15) list(35.4 15) list(35.4 -0.2)))
dbCreatePolygon(cv list("met2" "drawing") list(list(43.8 0.62) list(43.8 15) list(44.2 15) list(44.2 0.62)))
dbCreatePolygon(cv list("met2" "drawing") list(list(51 -0.2) list(51 15) list(51.4 15) list(51.4 -0.2)))
dbCreatePolygon(cv list("met2" "drawing") list(list(83 -0.2) list(83 15) list(83.4 15) list(83.4 -0.2)))
dbCreatePolygon(cv list("met2" "drawing") list(list(41.8 -1.53) list(41.8 -1.13) list(44.2 -1.13) list(44.2 -1.53)))
dbCreatePolygon(cv list("met2" "drawing") list(list(41.8 -1.13) list(41.8 16.2) list(42.2 16.2) list(42.2 -1.13)))
dbCreatePolygon(cv list("met2" "drawing") list(list(44.6 -0.2) list(44.6 16.2) list(45 16.2) list(45 -0.2)))
dbCreatePolygon(cv list("met2" "drawing") list(list(49.8 -1.53) list(49.8 -1.13) list(52.2 -1.13) list(52.2 -1.53)))
dbCreatePolygon(cv list("met2" "drawing") list(list(49.8 -1.13) list(49.8 16.2) list(50.2 16.2) list(50.2 -1.13)))
dbCreatePolygon(cv list("met2" "drawing") list(list(52.6 -0.2) list(52.6 16.2) list(53 16.2) list(53 -0.2)))
dbCreatePolygon(cv list("met2" "drawing") list(list(57.8 -1.53) list(57.8 -1.13) list(60.2 -1.13) list(60.2 -1.53)))
dbCreatePolygon(cv list("met2" "drawing") list(list(57.8 -1.13) list(57.8 16.2) list(58.2 16.2) list(58.2 -1.13)))
dbCreatePolygon(cv list("met2" "drawing") list(list(60.6 -0.2) list(60.6 16.2) list(61 16.2) list(61 -0.2)))
dbCreatePolygon(cv list("met2" "drawing") list(list(65.8 -1.53) list(65.8 -1.13) list(68.2 -1.13) list(68.2 -1.53)))
dbCreatePolygon(cv list("met2" "drawing") list(list(65.8 -1.13) list(65.8 16.2) list(66.2 16.2) list(66.2 -1.13)))
dbCreatePolygon(cv list("met2" "drawing") list(list(68.6 -0.2) list(68.6 16.2) list(69 16.2) list(69 -0.2)))
dbCreatePolygon(cv list("met2" "drawing") list(list(73.8 -1.53) list(73.8 -1.13) list(76.2 -1.13) list(76.2 -1.53)))
dbCreatePolygon(cv list("met2" "drawing") list(list(73.8 -1.13) list(73.8 16.2) list(74.2 16.2) list(74.2 -1.13)))
dbCreatePolygon(cv list("met2" "drawing") list(list(76.6 -0.2) list(76.6 16.2) list(77 16.2) list(77 -0.2)))
dbCreatePolygon(cv list("met2" "drawing") list(list(81.8 -1.53) list(81.8 -1.13) list(84.2 -1.13) list(84.2 -1.53)))
dbCreatePolygon(cv list("met2" "drawing") list(list(81.8 -1.13) list(81.8 16.2) list(82.2 16.2) list(82.2 -1.13)))
dbCreatePolygon(cv list("met2" "drawing") list(list(84.6 -0.2) list(84.6 16.2) list(85 16.2) list(85 -0.2)))
dbCreatePolygon(cv list("met2" "drawing") list(list(1.8 -2.985) list(1.8 -2.585) list(4.2 -2.585) list(4.2 -2.985)))
dbCreatePolygon(cv list("met2" "drawing") list(list(1.8 -2.585) list(1.8 17.4) list(2.2 17.4) list(2.2 -2.585)))
dbCreatePolygon(cv list("met2" "drawing") list(list(4.6 -0.2) list(4.6 17.4) list(5 17.4) list(5 -0.2)))
dbCreatePolygon(cv list("met2" "drawing") list(list(9.8 -1.985) list(9.8 -1.585) list(12.2 -1.585) list(12.2 -1.985)))
dbCreatePolygon(cv list("met2" "drawing") list(list(9.8 -1.585) list(9.8 17.4) list(10.2 17.4) list(10.2 -1.585)))
dbCreatePolygon(cv list("met2" "drawing") list(list(17.8 -1.985) list(17.8 -1.585) list(20.2 -1.585) list(20.2 -1.985)))
dbCreatePolygon(cv list("met2" "drawing") list(list(17.8 -1.585) list(17.8 17.4) list(18.2 17.4) list(18.2 -1.585)))
dbCreatePolygon(cv list("met2" "drawing") list(list(25.8 -1.485) list(25.8 -1.085) list(28.2 -1.085) list(28.2 -1.485)))
dbCreatePolygon(cv list("met2" "drawing") list(list(25.8 -1.085) list(25.8 17.4) list(26.2 17.4) list(26.2 -1.085)))
dbCreatePolygon(cv list("met2" "drawing") list(list(33.8 -1.485) list(33.8 -1.085) list(36.2 -1.085) list(36.2 -1.485)))
dbCreatePolygon(cv list("met2" "drawing") list(list(33.8 -1.085) list(33.8 17.4) list(34.2 17.4) list(34.2 -1.085)))
dbCreatePolygon(cv list("met2" "drawing") list(list(3 -0.2) list(3 18.6) list(3.4 18.6) list(3.4 -0.2)))
dbCreatePolygon(cv list("met2" "drawing") list(list(12.6 -0.2) list(12.6 18.6) list(13 18.6) list(13 -0.2)))
dbCreatePolygon(cv list("met2" "drawing") list(list(20.6 -0.2) list(20.6 18.6) list(21 18.6) list(21 -0.2)))
dbCreatePolygon(cv list("met2" "drawing") list(list(19 -0.2) list(19 19.8) list(19.4 19.8) list(19.4 -0.2)))
dbCreatePolygon(cv list("met2" "drawing") list(list(28.6 -0.2) list(28.6 19.8) list(29 19.8) list(29 -0.2)))
dbCreatePolygon(cv list("met2" "drawing") list(list(59 -0.2) list(59 19.8) list(59.4 19.8) list(59.4 -0.2)))
dbCreatePolygon(cv list("met2" "drawing") list(list(11 -0.2) list(11 21) list(11.4 21) list(11.4 -0.2)))
dbCreatePolygon(cv list("met2" "drawing") list(list(36.6 -0.2) list(36.6 21) list(37 21) list(37 -0.2)))
dbCreatePolygon(cv list("met2" "drawing") list(list(67 -0.2) list(67 21) list(67.4 21) list(67.4 -0.2)))
dbCreatePolygon(cv list("via2" "gds_44") list(list(11.9 9.9) list(11.9 10.1) list(12.1 10.1) list(12.1 9.9)))
dbCreatePolygon(cv list("via2" "gds_44") list(list(19.9 11.1) list(19.9 11.3) list(20.1 11.3) list(20.1 11.1)))
dbCreatePolygon(cv list("via2" "gds_44") list(list(3.9 12.3) list(3.9 12.5) list(4.1 12.5) list(4.1 12.3)))
dbCreatePolygon(cv list("via2" "gds_44") list(list(59.9 12.3) list(59.9 12.5) list(60.1 12.5) list(60.1 12.3)))
dbCreatePolygon(cv list("via2" "gds_44") list(list(67.9 12.3) list(67.9 12.5) list(68.1 12.5) list(68.1 12.3)))
dbCreatePolygon(cv list("via2" "gds_44") list(list(75.9 12.3) list(75.9 12.5) list(76.1 12.5) list(76.1 12.3)))
dbCreatePolygon(cv list("via2" "gds_44") list(list(83.9 12.3) list(83.9 12.5) list(84.1 12.5) list(84.1 12.3)))
dbCreatePolygon(cv list("via2" "gds_44") list(list(27.1 13.5) list(27.1 13.7) list(27.3 13.7) list(27.3 13.5)))
dbCreatePolygon(cv list("via2" "gds_44") list(list(35.9 13.5) list(35.9 13.7) list(36.1 13.7) list(36.1 13.5)))
dbCreatePolygon(cv list("via2" "gds_44") list(list(43.1 13.5) list(43.1 13.7) list(43.3 13.7) list(43.3 13.5)))
dbCreatePolygon(cv list("via2" "gds_44") list(list(51.9 13.5) list(51.9 13.7) list(52.1 13.7) list(52.1 13.5)))
dbCreatePolygon(cv list("via2" "gds_44") list(list(75.1 13.5) list(75.1 13.7) list(75.3 13.7) list(75.3 13.5)))
dbCreatePolygon(cv list("via2" "gds_44") list(list(27.9 14.7) list(27.9 14.9) list(28.1 14.9) list(28.1 14.7)))
dbCreatePolygon(cv list("via2" "gds_44") list(list(35.1 14.7) list(35.1 14.9) list(35.3 14.9) list(35.3 14.7)))
dbCreatePolygon(cv list("via2" "gds_44") list(list(43.9 14.7) list(43.9 14.9) list(44.1 14.9) list(44.1 14.7)))
dbCreatePolygon(cv list("via2" "gds_44") list(list(51.1 14.7) list(51.1 14.9) list(51.3 14.9) list(51.3 14.7)))
dbCreatePolygon(cv list("via2" "gds_44") list(list(83.1 14.7) list(83.1 14.9) list(83.3 14.9) list(83.3 14.7)))
dbCreatePolygon(cv list("via2" "gds_44") list(list(41.9 15.9) list(41.9 16.1) list(42.1 16.1) list(42.1 15.9)))
dbCreatePolygon(cv list("via2" "gds_44") list(list(44.7 15.9) list(44.7 16.1) list(44.9 16.1) list(44.9 15.9)))
dbCreatePolygon(cv list("via2" "gds_44") list(list(49.9 15.9) list(49.9 16.1) list(50.1 16.1) list(50.1 15.9)))
dbCreatePolygon(cv list("via2" "gds_44") list(list(52.7 15.9) list(52.7 16.1) list(52.9 16.1) list(52.9 15.9)))
dbCreatePolygon(cv list("via2" "gds_44") list(list(57.9 15.9) list(57.9 16.1) list(58.1 16.1) list(58.1 15.9)))
dbCreatePolygon(cv list("via2" "gds_44") list(list(60.7 15.9) list(60.7 16.1) list(60.9 16.1) list(60.9 15.9)))
dbCreatePolygon(cv list("via2" "gds_44") list(list(65.9 15.9) list(65.9 16.1) list(66.1 16.1) list(66.1 15.9)))
dbCreatePolygon(cv list("via2" "gds_44") list(list(68.7 15.9) list(68.7 16.1) list(68.9 16.1) list(68.9 15.9)))
dbCreatePolygon(cv list("via2" "gds_44") list(list(73.9 15.9) list(73.9 16.1) list(74.1 16.1) list(74.1 15.9)))
dbCreatePolygon(cv list("via2" "gds_44") list(list(76.7 15.9) list(76.7 16.1) list(76.9 16.1) list(76.9 15.9)))
dbCreatePolygon(cv list("via2" "gds_44") list(list(81.9 15.9) list(81.9 16.1) list(82.1 16.1) list(82.1 15.9)))
dbCreatePolygon(cv list("via2" "gds_44") list(list(84.7 15.9) list(84.7 16.1) list(84.9 16.1) list(84.9 15.9)))
dbCreatePolygon(cv list("via2" "gds_44") list(list(1.9 17.1) list(1.9 17.3) list(2.1 17.3) list(2.1 17.1)))
dbCreatePolygon(cv list("via2" "gds_44") list(list(4.7 17.1) list(4.7 17.3) list(4.9 17.3) list(4.9 17.1)))
dbCreatePolygon(cv list("via2" "gds_44") list(list(9.9 17.1) list(9.9 17.3) list(10.1 17.3) list(10.1 17.1)))
dbCreatePolygon(cv list("via2" "gds_44") list(list(17.9 17.1) list(17.9 17.3) list(18.1 17.3) list(18.1 17.1)))
dbCreatePolygon(cv list("via2" "gds_44") list(list(25.9 17.1) list(25.9 17.3) list(26.1 17.3) list(26.1 17.1)))
dbCreatePolygon(cv list("via2" "gds_44") list(list(33.9 17.1) list(33.9 17.3) list(34.1 17.3) list(34.1 17.1)))
dbCreatePolygon(cv list("via2" "gds_44") list(list(3.1 18.3) list(3.1 18.5) list(3.3 18.5) list(3.3 18.3)))
dbCreatePolygon(cv list("via2" "gds_44") list(list(12.7 18.3) list(12.7 18.5) list(12.9 18.5) list(12.9 18.3)))
dbCreatePolygon(cv list("via2" "gds_44") list(list(20.7 18.3) list(20.7 18.5) list(20.9 18.5) list(20.9 18.3)))
dbCreatePolygon(cv list("via2" "gds_44") list(list(19.1 19.5) list(19.1 19.7) list(19.3 19.7) list(19.3 19.5)))
dbCreatePolygon(cv list("via2" "gds_44") list(list(28.7 19.5) list(28.7 19.7) list(28.9 19.7) list(28.9 19.5)))
dbCreatePolygon(cv list("via2" "gds_44") list(list(59.1 19.5) list(59.1 19.7) list(59.3 19.7) list(59.3 19.5)))
dbCreatePolygon(cv list("via2" "gds_44") list(list(11.1 20.7) list(11.1 20.9) list(11.3 20.9) list(11.3 20.7)))
dbCreatePolygon(cv list("via2" "gds_44") list(list(36.7 20.7) list(36.7 20.9) list(36.9 20.9) list(36.9 20.7)))
dbCreatePolygon(cv list("via2" "gds_44") list(list(67.1 20.7) list(67.1 20.9) list(67.3 20.9) list(67.3 20.7)))
dbCreatePolygon(cv list("met3" "drawing") list(list(11.5 9.75) list(11.5 10.25) list(12.5 10.25) list(12.5 9.75)))
dbCreatePolygon(cv list("met3" "drawing") list(list(19.5 10.95) list(19.5 11.45) list(20.5 11.45) list(20.5 10.95)))
dbCreatePolygon(cv list("met3" "drawing") list(list(3.75 12.15) list(3.75 12.65) list(84.25 12.65) list(84.25 12.15)))
dbCreatePolygon(cv list("met3" "drawing") list(list(26.95 13.35) list(26.95 13.85) list(75.45 13.85) list(75.45 13.35)))
dbCreatePolygon(cv list("met3" "drawing") list(list(27.75 14.55) list(27.75 15.05) list(83.45 15.05) list(83.45 14.55)))
dbCreatePolygon(cv list("met3" "drawing") list(list(41.75 15.75) list(41.75 16.25) list(85.05 16.25) list(85.05 15.75)))
dbCreatePolygon(cv list("met3" "drawing") list(list(1.75 16.95) list(1.75 17.45) list(34.25 17.45) list(34.25 16.95)))
dbCreatePolygon(cv list("met3" "drawing") list(list(2.95 18.15) list(2.95 18.65) list(21.05 18.65) list(21.05 18.15)))
dbCreatePolygon(cv list("met3" "drawing") list(list(18.95 19.35) list(18.95 19.85) list(59.45 19.85) list(59.45 19.35)))
dbCreatePolygon(cv list("met3" "drawing") list(list(10.95 20.55) list(10.95 21.05) list(67.45 21.05) list(67.45 20.55)))
dbCreateLabel(cv list("met3" "label") list(12 10) "VINP" "centerCenter" "R0" "roman" 0.12)
net=dbCreateNet(cv "VINP")
dbCreateTerm(net "VINP" "input")
pin=dbCreateRect(cv list("met3" "drawing") list(list(11.8 9.8) list(12.2 10.2)))
dbCreatePin(net pin)
dbCreateLabel(cv list("met3" "label") list(20 11.2) "VINN" "centerCenter" "R0" "roman" 0.12)
net=dbCreateNet(cv "VINN")
dbCreateTerm(net "VINN" "input")
pin=dbCreateRect(cv list("met3" "drawing") list(list(19.8 11) list(20.2 11.4)))
dbCreatePin(net pin)
dbCreateLabel(cv list("met3" "label") list(4 12.4) "CLK" "centerCenter" "R0" "roman" 0.12)
net=dbCreateNet(cv "CLK")
dbCreateTerm(net "CLK" "input")
pin=dbCreateRect(cv list("met3" "drawing") list(list(3.8 12.2) list(4.2 12.6)))
dbCreatePin(net pin)
dbCreateLabel(cv list("met3" "label") list(27.2 13.6) "OUTP" "centerCenter" "R0" "roman" 0.12)
net=dbCreateNet(cv "OUTP")
dbCreateTerm(net "OUTP" "output")
pin=dbCreateRect(cv list("met3" "drawing") list(list(27 13.4) list(27.4 13.8)))
dbCreatePin(net pin)
dbCreateLabel(cv list("met3" "label") list(28 14.8) "OUTN" "centerCenter" "R0" "roman" 0.12)
net=dbCreateNet(cv "OUTN")
dbCreateTerm(net "OUTN" "output")
pin=dbCreateRect(cv list("met3" "drawing") list(list(27.8 14.6) list(28.2 15)))
dbCreatePin(net pin)
dbCreateLabel(cv list("met3" "label") list(42 16) "VDD" "centerCenter" "R0" "roman" 0.12)
net=dbCreateNet(cv "VDD")
dbCreateTerm(net "VDD" "inputOutput")
pin=dbCreateRect(cv list("met3" "drawing") list(list(41.8 15.8) list(42.2 16.2)))
dbCreatePin(net pin)
dbCreateLabel(cv list("met3" "label") list(2 17.2) "VSS" "centerCenter" "R0" "roman" 0.12)
net=dbCreateNet(cv "VSS")
dbCreateTerm(net "VSS" "inputOutput")
pin=dbCreateRect(cv list("met3" "drawing") list(list(1.8 17) list(2.2 17.4)))
dbCreatePin(net pin)
dbSave(cv) sprintf(nil "%d shapes %d nets %d terminals bBox %L" length(cv~>shapes) length(cv~>nets) length(cv~>terminals) cv~>bBox)))
