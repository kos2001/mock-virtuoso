* NGSPICE file created from extracted.ext - technology: sky130A

.subckt strongarm_sky130 VINP VINN CLK OUTP OUTN VDD VSS
X0 VDD.t9 OUTN.t3 OUTP.t1 VDD.t8 sky130_fd_pr__pfet_01v8 ad=0.29 pd=2.58 as=0.29 ps=2.58 w=1 l=0.15
X1 VDD.t3 CLK OUTN.t0 VDD.t2 sky130_fd_pr__pfet_01v8 ad=0.29 pd=2.58 as=0.29 ps=2.58 w=1 l=0.15
X2 VDD.t5 CLK OUTP.t0 VDD.t4 sky130_fd_pr__pfet_01v8 ad=0.29 pd=2.58 as=0.29 ps=2.58 w=1 l=0.15
X3 a_727_n400.t2 VINN a_3927_n200.t1 VSS.t3 sky130_fd_pr__nfet_01v8 ad=0.58 pd=4.58 as=0.58 ps=4.58 w=2 l=0.15
X4 a_2327_n200.t2 OUTP.t4 OUTN.t2 VSS.t5 sky130_fd_pr__nfet_01v8 ad=0.29 pd=2.58 as=0.29 ps=2.58 w=1 l=0.15
X5 VDD.t1 CLK a_2327_n200.t0 VDD.t0 sky130_fd_pr__pfet_01v8 ad=0.29 pd=2.58 as=0.29 ps=2.58 w=1 l=0.15
X6 a_3927_n200.t2 OUTN.t4 OUTP.t2 VSS.t4 sky130_fd_pr__nfet_01v8 ad=0.29 pd=2.58 as=0.29 ps=2.58 w=1 l=0.15
X7 VDD.t7 CLK a_3927_n200.t0 VDD.t6 sky130_fd_pr__pfet_01v8 ad=0.29 pd=2.58 as=0.29 ps=2.58 w=1 l=0.15
X8 VSS.t1 CLK a_727_n400.t0 VSS.t0 sky130_fd_pr__nfet_01v8 ad=1.16 pd=8.58 as=1.16 ps=8.58 w=4 l=0.15
X9 VDD.t11 OUTP.t3 OUTN.t1 VDD.t10 sky130_fd_pr__pfet_01v8 ad=0.29 pd=2.58 as=0.29 ps=2.58 w=1 l=0.15
X10 a_727_n400.t1 VINP a_2327_n200.t1 VSS.t2 sky130_fd_pr__nfet_01v8 ad=0.58 pd=4.58 as=0.58 ps=4.58 w=2 l=0.15
R0 OUTP.n2 OUTP.t0 246.262
R1 OUTP OUTP.n0 0.8277
R2 OUTP.n0 OUTP.n1 0.6773
R3 OUTP.n1 OUTP.n2 0.8277
R4 OUTP.n2 OUTP.t3 407.777
R5 OUTP.n1 OUTP.t1 244.081
R6 OUTP.n0 OUTP.t4 393.332
R7 OUTP OUTP.t2 99.5755
R8 OUTN.n2 OUTN.t0 247.464
R9 OUTN OUTN.n0 0.6773
R10 OUTN.n0 OUTN.n1 0.8277
R11 OUTN.n1 OUTN.n2 0.6773
R12 OUTN.n2 OUTN.t1 244.456
R13 OUTN.n1 OUTN.t3 408.152
R14 OUTN.n0 OUTN.t2 99.9505
R15 OUTN OUTN.t4 393.707
R16 a_3927_n200.n0 a_3927_n200.t0 248.814
R17 a_3927_n200.n0 a_3927_n200.t2 101.451
R18 a_3927_n200.t1 a_3927_n200.n0 107.82
R19 a_2327_n200.n0 a_2327_n200.t0 249.189
R20 a_2327_n200.n0 a_2327_n200.t2 101.826
R21 a_2327_n200.t1 a_2327_n200.n0 109.7
R22 a_727_n400.t0 a_727_n400.n0 37.287
R23 a_727_n400.n0 a_727_n400.t2 107.296
R24 a_727_n400.n0 a_727_n400.t1 106.543
R25 VDD.t3 VDD.n261 245.095
R26 VDD VDD.n42 0.2637
R27 VDD.n42 VDD.n85 0.4893
R28 VDD.n85 VDD.n86 0.2637
R29 VDD.n86 VDD.n129 0.4893
R30 VDD.n129 VDD.n130 0.2637
R31 VDD.n130 VDD.n173 0.4893
R32 VDD.n173 VDD.n174 0.2637
R33 VDD.n174 VDD.n217 0.4893
R34 VDD.n217 VDD.n218 0.2637
R35 VDD.n218 VDD.n261 0.4893
R36 VDD.n261 VDD.n260 23.1886
R37 VDD.n219 VDD.n239 185
R38 VDD.n220 VDD.n219 185
R39 VDD.n260 VDD.n220 6.4005
R40 VDD.n260 VDD.n221 6.4005
R41 VDD.n222 VDD.n242 185
R42 VDD.n221 VDD.n222 185
R43 VDD.n226 VDD.n224 72.7879
R44 VDD.n225 VDD.n224 185
R45 VDD.n223 VDD.n226 56.1076
R46 VDD.n228 VDD.n227 185
R47 VDD.n231 VDD.n229 72.7879
R48 VDD.n230 VDD.n229 185
R49 VDD.n223 VDD.n231 56.1076
R50 VDD.n233 VDD.n232 185
R51 VDD.n236 VDD.n234 72.7879
R52 VDD.n235 VDD.n234 185
R53 VDD.n236 VDD.n223 56.1076
R54 VDD.n238 VDD.n237 185
R55 VDD.n221 VDD.n238 76.424
R56 VDD.n238 VDD.n235 25.6005
R57 VDD.n235 VDD.n233 25.6005
R58 VDD.n233 VDD.n230 25.6005
R59 VDD.n230 VDD.n228 25.6005
R60 VDD.n228 VDD.n225 25.6005
R61 VDD.n239 VDD.n240 185
R62 VDD.n241 VDD.n240 185
R63 VDD.n242 VDD.n243 185
R64 VDD.n244 VDD.n243 185
R65 VDD.n241 VDD.n244 25.6005
R66 VDD.n225 VDD.n244 76.424
R67 VDD.n257 VDD.n245 185
R68 VDD.n246 VDD.n245 185
R69 VDD.n247 VDD.n255 72.7879
R70 VDD.n248 VDD.n247 185
R71 VDD.n255 VDD.n257 56.1076
R72 VDD.n250 VDD.n249 185
R73 VDD.n251 VDD.n256 72.7879
R74 VDD.n252 VDD.n251 185
R75 VDD.n257 VDD.n256 56.1076
R76 VDD.n254 VDD.n253 185
R77 VDD.n257 VDD.n258 185
R78 VDD.n259 VDD.n258 185
R79 VDD.n246 VDD.n248 25.6005
R80 VDD.n248 VDD.n250 25.6005
R81 VDD.n250 VDD.n252 25.6005
R82 VDD.n252 VDD.n254 25.6005
R83 VDD.n254 VDD.n259 25.6005
R84 VDD.n259 VDD.n241 76.424
R85 VDD.n220 VDD.n246 76.424
R86 VDD.n245 VDD.n247 240
R87 VDD.n255 VDD.n249 72.7879
R88 VDD.n249 VDD.n251 240
R89 VDD.n256 VDD.n253 72.7879
R90 VDD.n253 VDD.n258 240
R91 VDD.n245 VDD.n219 716.471
R92 VDD.n219 VDD.n222 240
R93 VDD.n222 VDD.n237 716.471
R94 VDD.n237 VDD.n236 72.7879
R95 VDD.n234 VDD.n232 240
R96 VDD.n232 VDD.n231 72.7879
R97 VDD.n229 VDD.n227 240
R98 VDD.n227 VDD.n226 72.7879
R99 VDD.n258 VDD.n240 716.471
R100 VDD.n240 VDD.n243 240
R101 VDD.n243 VDD.n224 716.471
R102 VDD.n257 VDD.n239 184.639
R103 VDD.n239 VDD.t2 50.6275
R104 VDD.n242 VDD.t2 50.6275
R105 VDD.n242 VDD.n223 184.639
R106 VDD.n218 VDD.t5 244.831
R107 VDD.n217 VDD.n216 23.1886
R108 VDD.n175 VDD.n195 185
R109 VDD.n176 VDD.n175 185
R110 VDD.n216 VDD.n176 6.4005
R111 VDD.n216 VDD.n177 6.4005
R112 VDD.n178 VDD.n198 185
R113 VDD.n177 VDD.n178 185
R114 VDD.n182 VDD.n180 72.7879
R115 VDD.n181 VDD.n180 185
R116 VDD.n179 VDD.n182 56.1076
R117 VDD.n184 VDD.n183 185
R118 VDD.n187 VDD.n185 72.7879
R119 VDD.n186 VDD.n185 185
R120 VDD.n179 VDD.n187 56.1076
R121 VDD.n189 VDD.n188 185
R122 VDD.n192 VDD.n190 72.7879
R123 VDD.n191 VDD.n190 185
R124 VDD.n192 VDD.n179 56.1076
R125 VDD.n194 VDD.n193 185
R126 VDD.n177 VDD.n194 76.424
R127 VDD.n194 VDD.n191 25.6005
R128 VDD.n191 VDD.n189 25.6005
R129 VDD.n189 VDD.n186 25.6005
R130 VDD.n186 VDD.n184 25.6005
R131 VDD.n184 VDD.n181 25.6005
R132 VDD.n195 VDD.n196 185
R133 VDD.n197 VDD.n196 185
R134 VDD.n198 VDD.n199 185
R135 VDD.n200 VDD.n199 185
R136 VDD.n197 VDD.n200 25.6005
R137 VDD.n181 VDD.n200 76.424
R138 VDD.n213 VDD.n201 185
R139 VDD.n202 VDD.n201 185
R140 VDD.n203 VDD.n211 72.7879
R141 VDD.n204 VDD.n203 185
R142 VDD.n211 VDD.n213 56.1076
R143 VDD.n206 VDD.n205 185
R144 VDD.n207 VDD.n212 72.7879
R145 VDD.n208 VDD.n207 185
R146 VDD.n213 VDD.n212 56.1076
R147 VDD.n210 VDD.n209 185
R148 VDD.n213 VDD.n214 185
R149 VDD.n215 VDD.n214 185
R150 VDD.n202 VDD.n204 25.6005
R151 VDD.n204 VDD.n206 25.6005
R152 VDD.n206 VDD.n208 25.6005
R153 VDD.n208 VDD.n210 25.6005
R154 VDD.n210 VDD.n215 25.6005
R155 VDD.n215 VDD.n197 76.424
R156 VDD.n176 VDD.n202 76.424
R157 VDD.n201 VDD.n203 240
R158 VDD.n211 VDD.n205 72.7879
R159 VDD.n205 VDD.n207 240
R160 VDD.n212 VDD.n209 72.7879
R161 VDD.n209 VDD.n214 240
R162 VDD.n201 VDD.n175 716.471
R163 VDD.n175 VDD.n178 240
R164 VDD.n178 VDD.n193 716.471
R165 VDD.n193 VDD.n192 72.7879
R166 VDD.n190 VDD.n188 240
R167 VDD.n188 VDD.n187 72.7879
R168 VDD.n185 VDD.n183 240
R169 VDD.n183 VDD.n182 72.7879
R170 VDD.n214 VDD.n196 716.471
R171 VDD.n196 VDD.n199 240
R172 VDD.n199 VDD.n180 716.471
R173 VDD.n213 VDD.n195 184.639
R174 VDD.n195 VDD.t4 50.6275
R175 VDD.t4 VDD.n198 50.6275
R176 VDD.n198 VDD.n179 184.639
R177 VDD.n174 VDD.t1 244.831
R178 VDD.n173 VDD.n172 23.1886
R179 VDD.n131 VDD.n151 185
R180 VDD.n132 VDD.n131 185
R181 VDD.n172 VDD.n132 6.4005
R182 VDD.n172 VDD.n133 6.4005
R183 VDD.n134 VDD.n154 185
R184 VDD.n133 VDD.n134 185
R185 VDD.n138 VDD.n136 72.7879
R186 VDD.n137 VDD.n136 185
R187 VDD.n135 VDD.n138 56.1076
R188 VDD.n140 VDD.n139 185
R189 VDD.n143 VDD.n141 72.7879
R190 VDD.n142 VDD.n141 185
R191 VDD.n135 VDD.n143 56.1076
R192 VDD.n145 VDD.n144 185
R193 VDD.n148 VDD.n146 72.7879
R194 VDD.n147 VDD.n146 185
R195 VDD.n148 VDD.n135 56.1076
R196 VDD.n150 VDD.n149 185
R197 VDD.n133 VDD.n150 76.424
R198 VDD.n150 VDD.n147 25.6005
R199 VDD.n147 VDD.n145 25.6005
R200 VDD.n145 VDD.n142 25.6005
R201 VDD.n142 VDD.n140 25.6005
R202 VDD.n140 VDD.n137 25.6005
R203 VDD.n151 VDD.n152 185
R204 VDD.n153 VDD.n152 185
R205 VDD.n154 VDD.n155 185
R206 VDD.n156 VDD.n155 185
R207 VDD.n153 VDD.n156 25.6005
R208 VDD.n137 VDD.n156 76.424
R209 VDD.n169 VDD.n157 185
R210 VDD.n158 VDD.n157 185
R211 VDD.n159 VDD.n167 72.7879
R212 VDD.n160 VDD.n159 185
R213 VDD.n167 VDD.n169 56.1076
R214 VDD.n162 VDD.n161 185
R215 VDD.n163 VDD.n168 72.7879
R216 VDD.n164 VDD.n163 185
R217 VDD.n169 VDD.n168 56.1076
R218 VDD.n166 VDD.n165 185
R219 VDD.n169 VDD.n170 185
R220 VDD.n171 VDD.n170 185
R221 VDD.n158 VDD.n160 25.6005
R222 VDD.n160 VDD.n162 25.6005
R223 VDD.n162 VDD.n164 25.6005
R224 VDD.n164 VDD.n166 25.6005
R225 VDD.n166 VDD.n171 25.6005
R226 VDD.n171 VDD.n153 76.424
R227 VDD.n132 VDD.n158 76.424
R228 VDD.n157 VDD.n159 240
R229 VDD.n167 VDD.n161 72.7879
R230 VDD.n161 VDD.n163 240
R231 VDD.n168 VDD.n165 72.7879
R232 VDD.n165 VDD.n170 240
R233 VDD.n157 VDD.n131 716.471
R234 VDD.n131 VDD.n134 240
R235 VDD.n134 VDD.n149 716.471
R236 VDD.n149 VDD.n148 72.7879
R237 VDD.n146 VDD.n144 240
R238 VDD.n144 VDD.n143 72.7879
R239 VDD.n141 VDD.n139 240
R240 VDD.n139 VDD.n138 72.7879
R241 VDD.n170 VDD.n152 716.471
R242 VDD.n152 VDD.n155 240
R243 VDD.n155 VDD.n136 716.471
R244 VDD.n169 VDD.n151 184.639
R245 VDD.n151 VDD.t0 50.6275
R246 VDD.t0 VDD.n154 50.6275
R247 VDD.n154 VDD.n135 184.639
R248 VDD.n130 VDD.t7 244.831
R249 VDD.n129 VDD.n128 23.1886
R250 VDD.n87 VDD.n107 185
R251 VDD.n88 VDD.n87 185
R252 VDD.n128 VDD.n88 6.4005
R253 VDD.n128 VDD.n89 6.4005
R254 VDD.n90 VDD.n110 185
R255 VDD.n89 VDD.n90 185
R256 VDD.n94 VDD.n92 72.7879
R257 VDD.n93 VDD.n92 185
R258 VDD.n91 VDD.n94 56.1076
R259 VDD.n96 VDD.n95 185
R260 VDD.n99 VDD.n97 72.7879
R261 VDD.n98 VDD.n97 185
R262 VDD.n91 VDD.n99 56.1076
R263 VDD.n101 VDD.n100 185
R264 VDD.n104 VDD.n102 72.7879
R265 VDD.n103 VDD.n102 185
R266 VDD.n104 VDD.n91 56.1076
R267 VDD.n106 VDD.n105 185
R268 VDD.n89 VDD.n106 76.424
R269 VDD.n106 VDD.n103 25.6005
R270 VDD.n103 VDD.n101 25.6005
R271 VDD.n101 VDD.n98 25.6005
R272 VDD.n98 VDD.n96 25.6005
R273 VDD.n96 VDD.n93 25.6005
R274 VDD.n107 VDD.n108 185
R275 VDD.n109 VDD.n108 185
R276 VDD.n110 VDD.n111 185
R277 VDD.n112 VDD.n111 185
R278 VDD.n109 VDD.n112 25.6005
R279 VDD.n93 VDD.n112 76.424
R280 VDD.n125 VDD.n113 185
R281 VDD.n114 VDD.n113 185
R282 VDD.n115 VDD.n123 72.7879
R283 VDD.n116 VDD.n115 185
R284 VDD.n123 VDD.n125 56.1076
R285 VDD.n118 VDD.n117 185
R286 VDD.n119 VDD.n124 72.7879
R287 VDD.n120 VDD.n119 185
R288 VDD.n125 VDD.n124 56.1076
R289 VDD.n122 VDD.n121 185
R290 VDD.n125 VDD.n126 185
R291 VDD.n127 VDD.n126 185
R292 VDD.n114 VDD.n116 25.6005
R293 VDD.n116 VDD.n118 25.6005
R294 VDD.n118 VDD.n120 25.6005
R295 VDD.n120 VDD.n122 25.6005
R296 VDD.n122 VDD.n127 25.6005
R297 VDD.n127 VDD.n109 76.424
R298 VDD.n88 VDD.n114 76.424
R299 VDD.n113 VDD.n115 240
R300 VDD.n123 VDD.n117 72.7879
R301 VDD.n117 VDD.n119 240
R302 VDD.n124 VDD.n121 72.7879
R303 VDD.n121 VDD.n126 240
R304 VDD.n113 VDD.n87 716.471
R305 VDD.n87 VDD.n90 240
R306 VDD.n90 VDD.n105 716.471
R307 VDD.n105 VDD.n104 72.7879
R308 VDD.n102 VDD.n100 240
R309 VDD.n100 VDD.n99 72.7879
R310 VDD.n97 VDD.n95 240
R311 VDD.n95 VDD.n94 72.7879
R312 VDD.n126 VDD.n108 716.471
R313 VDD.n108 VDD.n111 240
R314 VDD.n111 VDD.n92 716.471
R315 VDD.n125 VDD.n107 184.639
R316 VDD.n107 VDD.t6 50.6275
R317 VDD.n110 VDD.t6 50.6275
R318 VDD.n110 VDD.n91 184.639
R319 VDD.n86 VDD.t11 244.831
R320 VDD.n85 VDD.n84 23.1886
R321 VDD.n43 VDD.n63 185
R322 VDD.n44 VDD.n43 185
R323 VDD.n84 VDD.n44 6.4005
R324 VDD.n84 VDD.n45 6.4005
R325 VDD.n46 VDD.n66 185
R326 VDD.n45 VDD.n46 185
R327 VDD.n50 VDD.n48 72.7879
R328 VDD.n49 VDD.n48 185
R329 VDD.n47 VDD.n50 56.1076
R330 VDD.n52 VDD.n51 185
R331 VDD.n55 VDD.n53 72.7879
R332 VDD.n54 VDD.n53 185
R333 VDD.n47 VDD.n55 56.1076
R334 VDD.n57 VDD.n56 185
R335 VDD.n60 VDD.n58 72.7879
R336 VDD.n59 VDD.n58 185
R337 VDD.n60 VDD.n47 56.1076
R338 VDD.n62 VDD.n61 185
R339 VDD.n45 VDD.n62 76.424
R340 VDD.n62 VDD.n59 25.6005
R341 VDD.n59 VDD.n57 25.6005
R342 VDD.n57 VDD.n54 25.6005
R343 VDD.n54 VDD.n52 25.6005
R344 VDD.n52 VDD.n49 25.6005
R345 VDD.n63 VDD.n64 185
R346 VDD.n65 VDD.n64 185
R347 VDD.n66 VDD.n67 185
R348 VDD.n68 VDD.n67 185
R349 VDD.n65 VDD.n68 25.6005
R350 VDD.n49 VDD.n68 76.424
R351 VDD.n81 VDD.n69 185
R352 VDD.n70 VDD.n69 185
R353 VDD.n71 VDD.n79 72.7879
R354 VDD.n72 VDD.n71 185
R355 VDD.n79 VDD.n81 56.1076
R356 VDD.n74 VDD.n73 185
R357 VDD.n75 VDD.n80 72.7879
R358 VDD.n76 VDD.n75 185
R359 VDD.n81 VDD.n80 56.1076
R360 VDD.n78 VDD.n77 185
R361 VDD.n81 VDD.n82 185
R362 VDD.n83 VDD.n82 185
R363 VDD.n70 VDD.n72 25.6005
R364 VDD.n72 VDD.n74 25.6005
R365 VDD.n74 VDD.n76 25.6005
R366 VDD.n76 VDD.n78 25.6005
R367 VDD.n78 VDD.n83 25.6005
R368 VDD.n83 VDD.n65 76.424
R369 VDD.n44 VDD.n70 76.424
R370 VDD.n69 VDD.n71 240
R371 VDD.n79 VDD.n73 72.7879
R372 VDD.n73 VDD.n75 240
R373 VDD.n80 VDD.n77 72.7879
R374 VDD.n77 VDD.n82 240
R375 VDD.n69 VDD.n43 716.471
R376 VDD.n43 VDD.n46 240
R377 VDD.n46 VDD.n61 716.471
R378 VDD.n61 VDD.n60 72.7879
R379 VDD.n58 VDD.n56 240
R380 VDD.n56 VDD.n55 72.7879
R381 VDD.n53 VDD.n51 240
R382 VDD.n51 VDD.n50 72.7879
R383 VDD.n82 VDD.n64 716.471
R384 VDD.n64 VDD.n67 240
R385 VDD.n67 VDD.n48 716.471
R386 VDD.n81 VDD.n63 184.639
R387 VDD.n63 VDD.t10 50.6275
R388 VDD.t10 VDD.n66 50.6275
R389 VDD.n66 VDD.n47 184.639
R390 VDD.n42 VDD.t9 244.831
R391 VDD VDD.n41 23.1886
R392 VDD.n0 VDD.n20 185
R393 VDD.n1 VDD.n0 185
R394 VDD.n41 VDD.n1 6.4005
R395 VDD.n41 VDD.n2 6.4005
R396 VDD.n3 VDD.n23 185
R397 VDD.n2 VDD.n3 185
R398 VDD.n7 VDD.n5 72.7879
R399 VDD.n6 VDD.n5 185
R400 VDD.n4 VDD.n7 56.1076
R401 VDD.n9 VDD.n8 185
R402 VDD.n12 VDD.n10 72.7879
R403 VDD.n11 VDD.n10 185
R404 VDD.n4 VDD.n12 56.1076
R405 VDD.n14 VDD.n13 185
R406 VDD.n17 VDD.n15 72.7879
R407 VDD.n16 VDD.n15 185
R408 VDD.n17 VDD.n4 56.1076
R409 VDD.n19 VDD.n18 185
R410 VDD.n2 VDD.n19 76.424
R411 VDD.n19 VDD.n16 25.6005
R412 VDD.n16 VDD.n14 25.6005
R413 VDD.n14 VDD.n11 25.6005
R414 VDD.n11 VDD.n9 25.6005
R415 VDD.n9 VDD.n6 25.6005
R416 VDD.n20 VDD.n21 185
R417 VDD.n22 VDD.n21 185
R418 VDD.n23 VDD.n24 185
R419 VDD.n25 VDD.n24 185
R420 VDD.n22 VDD.n25 25.6005
R421 VDD.n6 VDD.n25 76.424
R422 VDD.n38 VDD.n26 185
R423 VDD.n27 VDD.n26 185
R424 VDD.n28 VDD.n36 72.7879
R425 VDD.n29 VDD.n28 185
R426 VDD.n36 VDD.n38 56.1076
R427 VDD.n31 VDD.n30 185
R428 VDD.n32 VDD.n37 72.7879
R429 VDD.n33 VDD.n32 185
R430 VDD.n38 VDD.n37 56.1076
R431 VDD.n35 VDD.n34 185
R432 VDD.n38 VDD.n39 185
R433 VDD.n40 VDD.n39 185
R434 VDD.n27 VDD.n29 25.6005
R435 VDD.n29 VDD.n31 25.6005
R436 VDD.n31 VDD.n33 25.6005
R437 VDD.n33 VDD.n35 25.6005
R438 VDD.n35 VDD.n40 25.6005
R439 VDD.n40 VDD.n22 76.424
R440 VDD.n1 VDD.n27 76.424
R441 VDD.n26 VDD.n28 240
R442 VDD.n36 VDD.n30 72.7879
R443 VDD.n30 VDD.n32 240
R444 VDD.n37 VDD.n34 72.7879
R445 VDD.n34 VDD.n39 240
R446 VDD.n26 VDD.n0 716.471
R447 VDD.n0 VDD.n3 240
R448 VDD.n3 VDD.n18 716.471
R449 VDD.n18 VDD.n17 72.7879
R450 VDD.n15 VDD.n13 240
R451 VDD.n13 VDD.n12 72.7879
R452 VDD.n10 VDD.n8 240
R453 VDD.n8 VDD.n7 72.7879
R454 VDD.n39 VDD.n21 716.471
R455 VDD.n21 VDD.n24 240
R456 VDD.n24 VDD.n5 716.471
R457 VDD.n38 VDD.n20 184.639
R458 VDD.n20 VDD.t8 50.6275
R459 VDD.n23 VDD.t8 50.6275
R460 VDD.n23 VDD.n4 184.639
R461 VSS.t1 VSS.n264 36.0096
R462 VSS VSS.n264 0.2637
R463 VSS.n264 VSS.n0 0.4893
R464 VSS.n0 VSS.n1 0.7525
R465 VSS.n1 VSS.n2 0.7525
R466 VSS.n2 VSS.n263 24.3016
R467 VSS.n20 VSS.n3 585
R468 VSS.n4 VSS.n3 585
R469 VSS.n263 VSS.n4 6.4005
R470 VSS.n263 VSS.n5 6.4005
R471 VSS.n23 VSS.n6 585
R472 VSS.n5 VSS.n6 585
R473 VSS.n7 VSS.n8 585
R474 VSS.n9 VSS.n8 585
R475 VSS.n12 VSS.n10 147.374
R476 VSS.n11 VSS.n10 585
R477 VSS.n7 VSS.n12 218.815
R478 VSS.n14 VSS.n13 585
R479 VSS.n17 VSS.n15 147.374
R480 VSS.n16 VSS.n15 585
R481 VSS.n17 VSS.n7 218.815
R482 VSS.n19 VSS.n18 585
R483 VSS.n5 VSS.n19 85.8358
R484 VSS.n19 VSS.n16 25.6005
R485 VSS.n16 VSS.n14 25.6005
R486 VSS.n14 VSS.n11 25.6005
R487 VSS.n11 VSS.n9 25.6005
R488 VSS.n20 VSS.n21 585
R489 VSS.n22 VSS.n21 585
R490 VSS.n23 VSS.n24 585
R491 VSS.n25 VSS.n24 585
R492 VSS.n22 VSS.n25 25.6005
R493 VSS.n9 VSS.n25 85.8358
R494 VSS.n26 VSS.n34 147.374
R495 VSS.n27 VSS.n26 585
R496 VSS.n34 VSS.n36 218.815
R497 VSS.n29 VSS.n28 585
R498 VSS.n30 VSS.n35 147.374
R499 VSS.n31 VSS.n30 585
R500 VSS.n36 VSS.n35 218.815
R501 VSS.n33 VSS.n32 585
R502 VSS.n36 VSS.n261 585
R503 VSS.n262 VSS.n261 585
R504 VSS.n27 VSS.n29 25.6005
R505 VSS.n29 VSS.n31 25.6005
R506 VSS.n31 VSS.n33 25.6005
R507 VSS.n33 VSS.n262 25.6005
R508 VSS.n262 VSS.n22 85.8358
R509 VSS.n4 VSS.n27 85.8358
R510 VSS.n34 VSS.n28 147.374
R511 VSS.n28 VSS.n30 394
R512 VSS.n35 VSS.n32 147.374
R513 VSS.n32 VSS.n261 394
R514 VSS.n26 VSS.n3 1321.06
R515 VSS.n3 VSS.n6 394
R516 VSS.n6 VSS.n18 1321.06
R517 VSS.n18 VSS.n17 147.374
R518 VSS.n15 VSS.n13 394
R519 VSS.n13 VSS.n12 147.374
R520 VSS.n10 VSS.n8 394
R521 VSS.n261 VSS.n21 1321.06
R522 VSS.n21 VSS.n24 394
R523 VSS.n24 VSS.n8 1321.06
R524 VSS.n37 VSS.n38 585
R525 VSS.n39 VSS.n38 585
R526 VSS.n40 VSS.n41 585
R527 VSS.n42 VSS.n41 585
R528 VSS.n46 VSS.n44 147.374
R529 VSS.n45 VSS.n44 585
R530 VSS.n43 VSS.n46 218.815
R531 VSS.n48 VSS.n47 585
R532 VSS.n51 VSS.n49 147.374
R533 VSS.n50 VSS.n49 585
R534 VSS.n43 VSS.n51 218.815
R535 VSS.n53 VSS.n52 585
R536 VSS.n56 VSS.n54 147.374
R537 VSS.n55 VSS.n54 585
R538 VSS.n43 VSS.n56 218.815
R539 VSS.n58 VSS.n57 585
R540 VSS.n61 VSS.n59 147.374
R541 VSS.n60 VSS.n59 585
R542 VSS.n43 VSS.n61 218.815
R543 VSS.n63 VSS.n62 585
R544 VSS.n66 VSS.n64 147.374
R545 VSS.n65 VSS.n64 585
R546 VSS.n43 VSS.n66 218.815
R547 VSS.n68 VSS.n67 585
R548 VSS.n71 VSS.n69 147.374
R549 VSS.n70 VSS.n69 585
R550 VSS.n43 VSS.n71 218.815
R551 VSS.n73 VSS.n72 585
R552 VSS.n76 VSS.n74 147.374
R553 VSS.n75 VSS.n74 585
R554 VSS.n76 VSS.n43 218.815
R555 VSS.n78 VSS.n77 585
R556 VSS.n40 VSS.n79 585
R557 VSS.n118 VSS.n79 585
R558 VSS.n37 VSS.n80 585
R559 VSS.n116 VSS.n80 585
R560 VSS.n112 VSS.n113 218.815
R561 VSS.n82 VSS.n81 585
R562 VSS.n112 VSS.n83 147.374
R563 VSS.n84 VSS.n83 585
R564 VSS.n113 VSS.n111 218.815
R565 VSS.n86 VSS.n85 585
R566 VSS.n111 VSS.n87 147.374
R567 VSS.n88 VSS.n87 585
R568 VSS.n113 VSS.n110 218.815
R569 VSS.n90 VSS.n89 585
R570 VSS.n110 VSS.n91 147.374
R571 VSS.n92 VSS.n91 585
R572 VSS.n113 VSS.n109 218.815
R573 VSS.n94 VSS.n93 585
R574 VSS.n109 VSS.n95 147.374
R575 VSS.n96 VSS.n95 585
R576 VSS.n113 VSS.n108 218.815
R577 VSS.n98 VSS.n97 585
R578 VSS.n108 VSS.n99 147.374
R579 VSS.n100 VSS.n99 585
R580 VSS.n113 VSS.n107 218.815
R581 VSS.n102 VSS.n101 585
R582 VSS.n107 VSS.n103 147.374
R583 VSS.n104 VSS.n103 585
R584 VSS.n105 VSS.n114 147.374
R585 VSS.n106 VSS.n105 585
R586 VSS.n113 VSS.n114 218.815
R587 VSS.n119 VSS.n115 585
R588 VSS.n120 VSS.n121 585
R589 VSS.n122 VSS.n121 585
R590 VSS.n123 VSS.n124 585
R591 VSS.n125 VSS.n124 585
R592 VSS.n129 VSS.n127 147.374
R593 VSS.n128 VSS.n127 585
R594 VSS.n126 VSS.n129 218.815
R595 VSS.n131 VSS.n130 585
R596 VSS.n134 VSS.n132 147.374
R597 VSS.n133 VSS.n132 585
R598 VSS.n126 VSS.n134 218.815
R599 VSS.n136 VSS.n135 585
R600 VSS.n139 VSS.n137 147.374
R601 VSS.n138 VSS.n137 585
R602 VSS.n126 VSS.n139 218.815
R603 VSS.n141 VSS.n140 585
R604 VSS.n144 VSS.n142 147.374
R605 VSS.n143 VSS.n142 585
R606 VSS.n144 VSS.n126 218.815
R607 VSS.n146 VSS.n145 585
R608 VSS.n123 VSS.n147 585
R609 VSS.n170 VSS.n147 585
R610 VSS.n148 VSS.n120 585
R611 VSS.n168 VSS.n148 585
R612 VSS.n165 VSS.n149 585
R613 VSS.n150 VSS.n149 585
R614 VSS.n151 VSS.n163 147.374
R615 VSS.n152 VSS.n151 585
R616 VSS.n163 VSS.n165 218.815
R617 VSS.n154 VSS.n153 585
R618 VSS.n155 VSS.n164 147.374
R619 VSS.n156 VSS.n155 585
R620 VSS.n165 VSS.n164 218.815
R621 VSS.n158 VSS.n157 585
R622 VSS.n165 VSS.n159 585
R623 VSS.n160 VSS.n159 585
R624 VSS.n161 VSS.n166 147.374
R625 VSS.n162 VSS.n161 585
R626 VSS.n165 VSS.n166 218.815
R627 VSS.n171 VSS.n167 585
R628 VSS.n172 VSS.n173 585
R629 VSS.n174 VSS.n173 585
R630 VSS.n175 VSS.n176 585
R631 VSS.n177 VSS.n176 585
R632 VSS.n181 VSS.n179 147.374
R633 VSS.n180 VSS.n179 585
R634 VSS.n178 VSS.n181 218.815
R635 VSS.n183 VSS.n182 585
R636 VSS.n186 VSS.n184 147.374
R637 VSS.n185 VSS.n184 585
R638 VSS.n178 VSS.n186 218.815
R639 VSS.n188 VSS.n187 585
R640 VSS.n191 VSS.n189 147.374
R641 VSS.n190 VSS.n189 585
R642 VSS.n178 VSS.n191 218.815
R643 VSS.n193 VSS.n192 585
R644 VSS.n196 VSS.n194 147.374
R645 VSS.n195 VSS.n194 585
R646 VSS.n196 VSS.n178 218.815
R647 VSS.n198 VSS.n197 585
R648 VSS.n175 VSS.n199 585
R649 VSS.n222 VSS.n199 585
R650 VSS.n200 VSS.n172 585
R651 VSS.n220 VSS.n200 585
R652 VSS.n217 VSS.n201 585
R653 VSS.n202 VSS.n201 585
R654 VSS.n203 VSS.n215 147.374
R655 VSS.n204 VSS.n203 585
R656 VSS.n215 VSS.n217 218.815
R657 VSS.n206 VSS.n205 585
R658 VSS.n207 VSS.n216 147.374
R659 VSS.n208 VSS.n207 585
R660 VSS.n217 VSS.n216 218.815
R661 VSS.n210 VSS.n209 585
R662 VSS.n217 VSS.n211 585
R663 VSS.n212 VSS.n211 585
R664 VSS.n213 VSS.n218 147.374
R665 VSS.n214 VSS.n213 585
R666 VSS.n217 VSS.n218 218.815
R667 VSS.n223 VSS.n219 585
R668 VSS.n224 VSS.n225 585
R669 VSS.n226 VSS.n225 585
R670 VSS.n227 VSS.n228 585
R671 VSS.n229 VSS.n228 585
R672 VSS.n230 VSS.n231 585
R673 VSS.n232 VSS.n231 585
R674 VSS.n235 VSS.n233 147.374
R675 VSS.n234 VSS.n233 585
R676 VSS.n230 VSS.n235 218.815
R677 VSS.n237 VSS.n236 585
R678 VSS.n240 VSS.n238 147.374
R679 VSS.n239 VSS.n238 585
R680 VSS.n240 VSS.n230 218.815
R681 VSS.n242 VSS.n241 585
R682 VSS.n227 VSS.n243 585
R683 VSS.n259 VSS.n243 585
R684 VSS.n224 VSS.n244 585
R685 VSS.n257 VSS.n244 585
R686 VSS.n245 VSS.n253 147.374
R687 VSS.n246 VSS.n245 585
R688 VSS.n253 VSS.n254 218.815
R689 VSS.n248 VSS.n247 585
R690 VSS.n254 VSS.n249 585
R691 VSS.n250 VSS.n249 585
R692 VSS.n251 VSS.n255 147.374
R693 VSS.n252 VSS.n251 585
R694 VSS.n254 VSS.n255 218.815
R695 VSS.n260 VSS.n256 585
R696 VSS.n113 VSS.n37 113.43
R697 VSS.n37 VSS.t0 31.1024
R698 VSS.t0 VSS.n40 31.1024
R699 VSS.n43 VSS.n40 113.43
R700 VSS.n43 VSS.n165 1174.55
R701 VSS.n165 VSS.n120 113.43
R702 VSS.n120 VSS.t2 31.1024
R703 VSS.n123 VSS.t2 31.1024
R704 VSS.n126 VSS.n123 113.43
R705 VSS.n126 VSS.n217 1174.55
R706 VSS.n217 VSS.n172 113.43
R707 VSS.n172 VSS.t3 31.1024
R708 VSS.n175 VSS.t3 31.1024
R709 VSS.n178 VSS.n175 113.43
R710 VSS.n178 VSS.n254 1174.55
R711 VSS.n254 VSS.n224 113.43
R712 VSS.n224 VSS.t4 31.1024
R713 VSS.n227 VSS.t4 31.1024
R714 VSS.n230 VSS.n227 113.43
R715 VSS.n230 VSS.n36 1174.55
R716 VSS.n36 VSS.n20 113.43
R717 VSS.n20 VSS.t5 31.1024
R718 VSS.t5 VSS.n23 31.1024
R719 VSS.n7 VSS.n23 113.43
R720 VSS.n246 VSS.n248 25.6005
R721 VSS.n248 VSS.n250 25.6005
R722 VSS.n250 VSS.n252 25.6005
R723 VSS.n252 VSS.n260 25.6005
R724 VSS.n257 VSS.n246 85.8358
R725 VSS.n258 VSS.n257 6.4005
R726 VSS.n258 VSS.n259 6.4005
R727 VSS.n259 VSS.n242 85.8358
R728 VSS.n242 VSS.n239 25.6005
R729 VSS.n239 VSS.n237 25.6005
R730 VSS.n237 VSS.n234 25.6005
R731 VSS.n234 VSS.n232 25.6005
R732 VSS.n260 VSS.n226 85.8358
R733 VSS.n226 VSS.n229 25.6005
R734 VSS.n232 VSS.n229 85.8358
R735 VSS.n2 VSS.n258 23.5496
R736 VSS.n253 VSS.n247 147.374
R737 VSS.n247 VSS.n249 394
R738 VSS.n249 VSS.n251 394
R739 VSS.n255 VSS.n256 147.374
R740 VSS.n245 VSS.n244 1321.06
R741 VSS.n244 VSS.n243 394
R742 VSS.n243 VSS.n241 1321.06
R743 VSS.n241 VSS.n240 147.374
R744 VSS.n238 VSS.n236 394
R745 VSS.n236 VSS.n235 147.374
R746 VSS.n233 VSS.n231 394
R747 VSS.n256 VSS.n225 1321.06
R748 VSS.n225 VSS.n228 394
R749 VSS.n228 VSS.n231 1321.06
R750 VSS.n202 VSS.n204 25.6005
R751 VSS.n204 VSS.n206 25.6005
R752 VSS.n206 VSS.n208 25.6005
R753 VSS.n208 VSS.n210 25.6005
R754 VSS.n210 VSS.n212 25.6005
R755 VSS.n212 VSS.n214 25.6005
R756 VSS.n214 VSS.n223 25.6005
R757 VSS.n220 VSS.n202 85.0829
R758 VSS.n221 VSS.n220 6.4005
R759 VSS.n221 VSS.n222 6.4005
R760 VSS.n222 VSS.n198 85.0829
R761 VSS.n198 VSS.n195 25.6005
R762 VSS.n195 VSS.n193 25.6005
R763 VSS.n193 VSS.n190 25.6005
R764 VSS.n190 VSS.n188 25.6005
R765 VSS.n188 VSS.n185 25.6005
R766 VSS.n185 VSS.n183 25.6005
R767 VSS.n183 VSS.n180 25.6005
R768 VSS.n223 VSS.n174 85.0829
R769 VSS.n174 VSS.n177 25.6005
R770 VSS.n180 VSS.n177 85.0829
R771 VSS.n1 VSS.n221 23.7058
R772 VSS.n201 VSS.n203 394
R773 VSS.n215 VSS.n205 147.374
R774 VSS.n205 VSS.n207 394
R775 VSS.n216 VSS.n209 147.374
R776 VSS.n209 VSS.n211 394
R777 VSS.n211 VSS.n213 394
R778 VSS.n218 VSS.n219 147.374
R779 VSS.n201 VSS.n200 1309.47
R780 VSS.n200 VSS.n199 394
R781 VSS.n199 VSS.n197 1309.47
R782 VSS.n197 VSS.n196 147.374
R783 VSS.n194 VSS.n192 394
R784 VSS.n192 VSS.n191 147.374
R785 VSS.n189 VSS.n187 394
R786 VSS.n187 VSS.n186 147.374
R787 VSS.n184 VSS.n182 394
R788 VSS.n182 VSS.n181 147.374
R789 VSS.n219 VSS.n173 1309.47
R790 VSS.n173 VSS.n176 394
R791 VSS.n176 VSS.n179 1309.47
R792 VSS.n150 VSS.n152 25.6005
R793 VSS.n152 VSS.n154 25.6005
R794 VSS.n154 VSS.n156 25.6005
R795 VSS.n156 VSS.n158 25.6005
R796 VSS.n158 VSS.n160 25.6005
R797 VSS.n160 VSS.n162 25.6005
R798 VSS.n162 VSS.n171 25.6005
R799 VSS.n168 VSS.n150 85.0829
R800 VSS.n169 VSS.n168 6.4005
R801 VSS.n169 VSS.n170 6.4005
R802 VSS.n170 VSS.n146 85.0829
R803 VSS.n146 VSS.n143 25.6005
R804 VSS.n143 VSS.n141 25.6005
R805 VSS.n141 VSS.n138 25.6005
R806 VSS.n138 VSS.n136 25.6005
R807 VSS.n136 VSS.n133 25.6005
R808 VSS.n133 VSS.n131 25.6005
R809 VSS.n131 VSS.n128 25.6005
R810 VSS.n171 VSS.n122 85.0829
R811 VSS.n122 VSS.n125 25.6005
R812 VSS.n128 VSS.n125 85.0829
R813 VSS.n0 VSS.n169 23.7058
R814 VSS.n149 VSS.n151 394
R815 VSS.n163 VSS.n153 147.374
R816 VSS.n153 VSS.n155 394
R817 VSS.n164 VSS.n157 147.374
R818 VSS.n157 VSS.n159 394
R819 VSS.n159 VSS.n161 394
R820 VSS.n166 VSS.n167 147.374
R821 VSS.n149 VSS.n148 1309.47
R822 VSS.n148 VSS.n147 394
R823 VSS.n147 VSS.n145 1309.47
R824 VSS.n145 VSS.n144 147.374
R825 VSS.n142 VSS.n140 394
R826 VSS.n140 VSS.n139 147.374
R827 VSS.n137 VSS.n135 394
R828 VSS.n135 VSS.n134 147.374
R829 VSS.n132 VSS.n130 394
R830 VSS.n130 VSS.n129 147.374
R831 VSS.n167 VSS.n121 1309.47
R832 VSS.n121 VSS.n124 394
R833 VSS.n124 VSS.n127 1309.47
R834 VSS.n82 VSS.n84 25.6005
R835 VSS.n84 VSS.n86 25.6005
R836 VSS.n86 VSS.n88 25.6005
R837 VSS.n88 VSS.n90 25.6005
R838 VSS.n90 VSS.n92 25.6005
R839 VSS.n92 VSS.n94 25.6005
R840 VSS.n94 VSS.n96 25.6005
R841 VSS.n96 VSS.n98 25.6005
R842 VSS.n98 VSS.n100 25.6005
R843 VSS.n100 VSS.n102 25.6005
R844 VSS.n102 VSS.n104 25.6005
R845 VSS.n104 VSS.n106 25.6005
R846 VSS.n106 VSS.n119 25.6005
R847 VSS.n116 VSS.n82 83.577
R848 VSS.n117 VSS.n116 6.4005
R849 VSS.n117 VSS.n118 6.4005
R850 VSS.n118 VSS.n78 83.577
R851 VSS.n78 VSS.n75 25.6005
R852 VSS.n75 VSS.n73 25.6005
R853 VSS.n73 VSS.n70 25.6005
R854 VSS.n70 VSS.n68 25.6005
R855 VSS.n68 VSS.n65 25.6005
R856 VSS.n65 VSS.n63 25.6005
R857 VSS.n63 VSS.n60 25.6005
R858 VSS.n60 VSS.n58 25.6005
R859 VSS.n58 VSS.n55 25.6005
R860 VSS.n55 VSS.n53 25.6005
R861 VSS.n53 VSS.n50 25.6005
R862 VSS.n50 VSS.n48 25.6005
R863 VSS.n48 VSS.n45 25.6005
R864 VSS.n119 VSS.n39 83.577
R865 VSS.n39 VSS.n42 25.6005
R866 VSS.n45 VSS.n42 83.577
R867 VSS VSS.n117 24.0183
R868 VSS.n81 VSS.n112 147.374
R869 VSS.n83 VSS.n85 394
R870 VSS.n85 VSS.n111 147.374
R871 VSS.n87 VSS.n89 394
R872 VSS.n89 VSS.n110 147.374
R873 VSS.n91 VSS.n93 394
R874 VSS.n93 VSS.n109 147.374
R875 VSS.n95 VSS.n97 394
R876 VSS.n97 VSS.n108 147.374
R877 VSS.n99 VSS.n101 394
R878 VSS.n101 VSS.n107 147.374
R879 VSS.n103 VSS.n105 394
R880 VSS.n114 VSS.n115 147.374
R881 VSS.n81 VSS.n80 1286.29
R882 VSS.n80 VSS.n79 394
R883 VSS.n79 VSS.n77 1286.29
R884 VSS.n77 VSS.n76 147.374
R885 VSS.n74 VSS.n72 394
R886 VSS.n72 VSS.n71 147.374
R887 VSS.n69 VSS.n67 394
R888 VSS.n67 VSS.n66 147.374
R889 VSS.n64 VSS.n62 394
R890 VSS.n62 VSS.n61 147.374
R891 VSS.n59 VSS.n57 394
R892 VSS.n57 VSS.n56 147.374
R893 VSS.n54 VSS.n52 394
R894 VSS.n52 VSS.n51 147.374
R895 VSS.n49 VSS.n47 394
R896 VSS.n47 VSS.n46 147.374
R897 VSS.n115 VSS.n38 1286.29
R898 VSS.n38 VSS.n41 394
R899 VSS.n41 VSS.n44 1286.29
C0 VINN OUTP 0
C1 VINN OUTN 0
C2 CLK VINP 0.01687f
C3 CLK OUTP 2.50332f
C4 VDD CLK 4.09785f
C5 CLK OUTN 1.00187f
C6 VINP VINN 0.00246f
C7 VDD OUTP 2.77508f
C8 OUTN OUTP 3.93972f
C9 VDD OUTN 4.54042f
C10 CLK VINN 0.03617f
C11 OUTP VSS 4.40439f
C12 OUTN VSS 4.85584f
C13 VDD VSS 18.07676f
C14 VDD.t3 VSS 3.29942f
C15 VDD.n0 VSS 0.00934f
C16 VDD.n1 VSS 0.00934f
C17 VDD.n2 VSS 0.00934f
C18 VDD.n3 VSS 0.00934f
C19 VDD.n4 VSS 0.14175f
C20 VDD.n5 VSS 0.00958f
C21 VDD.n6 VSS 0.00958f
C22 VDD.n8 VSS 0.00447f
C23 VDD.n9 VSS 0.00447f
C24 VDD.n10 VSS 0.00447f
C25 VDD.n11 VSS 0.00447f
C26 VDD.n13 VSS 0.00447f
C27 VDD.n14 VSS 0.00447f
C28 VDD.n15 VSS 0.00447f
C29 VDD.n16 VSS 0.00447f
C30 VDD.n18 VSS 0.00958f
C31 VDD.n19 VSS 0.00958f
C32 VDD.n20 VSS 0.09737f
C33 VDD.n21 VSS 0.00934f
C34 VDD.n22 VSS 0.00934f
C35 VDD.n23 VSS 0.09737f
C36 VDD.n24 VSS 0.00934f
C37 VDD.n25 VSS 0.00934f
C38 VDD.n26 VSS 0.00958f
C39 VDD.n27 VSS 0.00958f
C40 VDD.n28 VSS 0.00447f
C41 VDD.n29 VSS 0.00447f
C42 VDD.n30 VSS 0.00447f
C43 VDD.n31 VSS 0.00447f
C44 VDD.n32 VSS 0.00447f
C45 VDD.n33 VSS 0.00447f
C46 VDD.n34 VSS 0.00447f
C47 VDD.n35 VSS 0.00447f
C48 VDD.n38 VSS 0.14175f
C49 VDD.t8 VSS 0.04191f
C50 VDD.n39 VSS 0.00958f
C51 VDD.n40 VSS 0.00958f
C52 VDD.n41 VSS 0.18081f
C53 VDD.t9 VSS 0.08333f
C54 VDD.n42 VSS 0.69703f
C55 VDD.n43 VSS 0.00934f
C56 VDD.n44 VSS 0.00934f
C57 VDD.n45 VSS 0.00934f
C58 VDD.n46 VSS 0.00934f
C59 VDD.n47 VSS 0.14175f
C60 VDD.n48 VSS 0.00958f
C61 VDD.n49 VSS 0.00958f
C62 VDD.n51 VSS 0.00447f
C63 VDD.n52 VSS 0.00447f
C64 VDD.n53 VSS 0.00447f
C65 VDD.n54 VSS 0.00447f
C66 VDD.n56 VSS 0.00447f
C67 VDD.n57 VSS 0.00447f
C68 VDD.n58 VSS 0.00447f
C69 VDD.n59 VSS 0.00447f
C70 VDD.n61 VSS 0.00958f
C71 VDD.n62 VSS 0.00958f
C72 VDD.n63 VSS 0.09737f
C73 VDD.n64 VSS 0.00934f
C74 VDD.n65 VSS 0.00934f
C75 VDD.n66 VSS 0.09737f
C76 VDD.n67 VSS 0.00934f
C77 VDD.n68 VSS 0.00934f
C78 VDD.n69 VSS 0.00958f
C79 VDD.n70 VSS 0.00958f
C80 VDD.n71 VSS 0.00447f
C81 VDD.n72 VSS 0.00447f
C82 VDD.n73 VSS 0.00447f
C83 VDD.n74 VSS 0.00447f
C84 VDD.n75 VSS 0.00447f
C85 VDD.n76 VSS 0.00447f
C86 VDD.n77 VSS 0.00447f
C87 VDD.n78 VSS 0.00447f
C88 VDD.n81 VSS 0.14175f
C89 VDD.t10 VSS 0.04191f
C90 VDD.n82 VSS 0.00958f
C91 VDD.n83 VSS 0.00958f
C92 VDD.n84 VSS 0.18081f
C93 VDD.n85 VSS 0.60046f
C94 VDD.t11 VSS 0.08558f
C95 VDD.n86 VSS 0.69703f
C96 VDD.n87 VSS 0.00934f
C97 VDD.n88 VSS 0.00934f
C98 VDD.n89 VSS 0.00934f
C99 VDD.n90 VSS 0.00934f
C100 VDD.n91 VSS 0.14175f
C101 VDD.n92 VSS 0.00958f
C102 VDD.n93 VSS 0.00958f
C103 VDD.n95 VSS 0.00447f
C104 VDD.n96 VSS 0.00447f
C105 VDD.n97 VSS 0.00447f
C106 VDD.n98 VSS 0.00447f
C107 VDD.n100 VSS 0.00447f
C108 VDD.n101 VSS 0.00447f
C109 VDD.n102 VSS 0.00447f
C110 VDD.n103 VSS 0.00447f
C111 VDD.n105 VSS 0.00958f
C112 VDD.n106 VSS 0.00958f
C113 VDD.n107 VSS 0.09737f
C114 VDD.n108 VSS 0.00934f
C115 VDD.n109 VSS 0.00934f
C116 VDD.n110 VSS 0.09737f
C117 VDD.n111 VSS 0.00934f
C118 VDD.n112 VSS 0.00934f
C119 VDD.n113 VSS 0.00958f
C120 VDD.n114 VSS 0.00958f
C121 VDD.n115 VSS 0.00447f
C122 VDD.n116 VSS 0.00447f
C123 VDD.n117 VSS 0.00447f
C124 VDD.n118 VSS 0.00447f
C125 VDD.n119 VSS 0.00447f
C126 VDD.n120 VSS 0.00447f
C127 VDD.n121 VSS 0.00447f
C128 VDD.n122 VSS 0.00447f
C129 VDD.n125 VSS 0.14175f
C130 VDD.t6 VSS 0.04191f
C131 VDD.n126 VSS 0.00958f
C132 VDD.n127 VSS 0.00958f
C133 VDD.n128 VSS 0.18081f
C134 VDD.n129 VSS 0.60046f
C135 VDD.t7 VSS 0.03569f
C136 VDD.n130 VSS 0.69703f
C137 VDD.n131 VSS 0.00934f
C138 VDD.n132 VSS 0.00934f
C139 VDD.n133 VSS 0.00934f
C140 VDD.n134 VSS 0.00934f
C141 VDD.n135 VSS 0.14175f
C142 VDD.n136 VSS 0.00958f
C143 VDD.n137 VSS 0.00958f
C144 VDD.n139 VSS 0.00447f
C145 VDD.n140 VSS 0.00447f
C146 VDD.n141 VSS 0.00447f
C147 VDD.n142 VSS 0.00447f
C148 VDD.n144 VSS 0.00447f
C149 VDD.n145 VSS 0.00447f
C150 VDD.n146 VSS 0.00447f
C151 VDD.n147 VSS 0.00447f
C152 VDD.n149 VSS 0.00958f
C153 VDD.n150 VSS 0.00958f
C154 VDD.n151 VSS 0.09737f
C155 VDD.n152 VSS 0.00934f
C156 VDD.n153 VSS 0.00934f
C157 VDD.n154 VSS 0.09737f
C158 VDD.n155 VSS 0.00934f
C159 VDD.n156 VSS 0.00934f
C160 VDD.n157 VSS 0.00958f
C161 VDD.n158 VSS 0.00958f
C162 VDD.n159 VSS 0.00447f
C163 VDD.n160 VSS 0.00447f
C164 VDD.n161 VSS 0.00447f
C165 VDD.n162 VSS 0.00447f
C166 VDD.n163 VSS 0.00447f
C167 VDD.n164 VSS 0.00447f
C168 VDD.n165 VSS 0.00447f
C169 VDD.n166 VSS 0.00447f
C170 VDD.n169 VSS 0.14175f
C171 VDD.t0 VSS 0.04191f
C172 VDD.n170 VSS 0.00958f
C173 VDD.n171 VSS 0.00958f
C174 VDD.n172 VSS 0.18081f
C175 VDD.n173 VSS 0.60046f
C176 VDD.t1 VSS 0.03569f
C177 VDD.n174 VSS 0.69703f
C178 VDD.n175 VSS 0.00934f
C179 VDD.n176 VSS 0.00934f
C180 VDD.n177 VSS 0.00934f
C181 VDD.n178 VSS 0.00934f
C182 VDD.n179 VSS 0.14175f
C183 VDD.n180 VSS 0.00958f
C184 VDD.n181 VSS 0.00958f
C185 VDD.n183 VSS 0.00447f
C186 VDD.n184 VSS 0.00447f
C187 VDD.n185 VSS 0.00447f
C188 VDD.n186 VSS 0.00447f
C189 VDD.n188 VSS 0.00447f
C190 VDD.n189 VSS 0.00447f
C191 VDD.n190 VSS 0.00447f
C192 VDD.n191 VSS 0.00447f
C193 VDD.n193 VSS 0.00958f
C194 VDD.n194 VSS 0.00958f
C195 VDD.n195 VSS 0.09737f
C196 VDD.n196 VSS 0.00934f
C197 VDD.n197 VSS 0.00934f
C198 VDD.n198 VSS 0.09737f
C199 VDD.n199 VSS 0.00934f
C200 VDD.n200 VSS 0.00934f
C201 VDD.n201 VSS 0.00958f
C202 VDD.n202 VSS 0.00958f
C203 VDD.n203 VSS 0.00447f
C204 VDD.n204 VSS 0.00447f
C205 VDD.n205 VSS 0.00447f
C206 VDD.n206 VSS 0.00447f
C207 VDD.n207 VSS 0.00447f
C208 VDD.n208 VSS 0.00447f
C209 VDD.n209 VSS 0.00447f
C210 VDD.n210 VSS 0.00447f
C211 VDD.n213 VSS 0.14175f
C212 VDD.t4 VSS 0.04191f
C213 VDD.n214 VSS 0.00958f
C214 VDD.n215 VSS 0.00958f
C215 VDD.n216 VSS 0.18081f
C216 VDD.n217 VSS 0.60046f
C217 VDD.t5 VSS 0.03569f
C218 VDD.n218 VSS 0.69703f
C219 VDD.n219 VSS 0.00934f
C220 VDD.n220 VSS 0.00934f
C221 VDD.n221 VSS 0.00934f
C222 VDD.n222 VSS 0.00934f
C223 VDD.n223 VSS 0.14175f
C224 VDD.n224 VSS 0.00958f
C225 VDD.n225 VSS 0.00958f
C226 VDD.n227 VSS 0.00447f
C227 VDD.n228 VSS 0.00447f
C228 VDD.n229 VSS 0.00447f
C229 VDD.n230 VSS 0.00447f
C230 VDD.n232 VSS 0.00447f
C231 VDD.n233 VSS 0.00447f
C232 VDD.n234 VSS 0.00447f
C233 VDD.n235 VSS 0.00447f
C234 VDD.n237 VSS 0.00958f
C235 VDD.n238 VSS 0.00958f
C236 VDD.n239 VSS 0.09737f
C237 VDD.n240 VSS 0.00934f
C238 VDD.n241 VSS 0.00934f
C239 VDD.n242 VSS 0.09737f
C240 VDD.n243 VSS 0.00934f
C241 VDD.n244 VSS 0.00934f
C242 VDD.n245 VSS 0.00958f
C243 VDD.n246 VSS 0.00958f
C244 VDD.n247 VSS 0.00447f
C245 VDD.n248 VSS 0.00447f
C246 VDD.n249 VSS 0.00447f
C247 VDD.n250 VSS 0.00447f
C248 VDD.n251 VSS 0.00447f
C249 VDD.n252 VSS 0.00447f
C250 VDD.n253 VSS 0.00447f
C251 VDD.n254 VSS 0.00447f
C252 VDD.n257 VSS 0.14175f
C253 VDD.t2 VSS 0.04191f
C254 VDD.n258 VSS 0.00958f
C255 VDD.n259 VSS 0.00958f
C256 VDD.n260 VSS 0.18081f
C257 VDD.n261 VSS 1.20604f
C258 a_727_n400.t0 VSS 0.22914f
C259 a_727_n400.t1 VSS 0.3408f
C260 a_727_n400.n0 VSS 2.25673f
C261 a_727_n400.t2 VSS 0.35107f
C262 a_2327_n200.t1 VSS 0.39783f
C263 a_2327_n200.t2 VSS 0.13109f
C264 a_2327_n200.n0 VSS 4.86843f
C265 a_2327_n200.t0 VSS 0.06527f
C266 a_3927_n200.t1 VSS 0.39609f
C267 a_3927_n200.t2 VSS 0.14161f
C268 a_3927_n200.n0 VSS 4.93463f
C269 a_3927_n200.t0 VSS 0.07676f
C270 OUTN.t0 VSS 3.36972f
C271 OUTN.t2 VSS 0.16791f
C272 OUTN.n0 VSS 1.76351f
C273 OUTN.n1 VSS 1.69335f
C274 OUTN.t1 VSS 0.126f
C275 OUTN.n2 VSS 5.27934f
C276 OUTP.t0 VSS 0.09746f
C277 OUTP.t2 VSS 0.1663f
C278 OUTP.n0 VSS 1.71916f
C279 OUTP.t1 VSS 0.12571f
C280 OUTP.n1 VSS 1.83846f
C281 OUTP.n2 VSS 4.61555f
.ends
